* NGSPICE file created from solar_energy_manager_top.ext - technology: sky130A

* Black-box entry subcircuit for sky130_fd_sc_hd__a21oi_1 abstract view
.subckt sky130_fd_sc_hd__a21oi_1 A1 A2 B1 VGND VNB VPB VPWR Y
.ends

* Black-box entry subcircuit for sky130_fd_sc_hd__dfrtp_4 abstract view
.subckt sky130_fd_sc_hd__dfrtp_4 CLK D RESET_B VGND VNB VPB VPWR Q
.ends

* Black-box entry subcircuit for sky130_fd_sc_hd__dfrtp_1 abstract view
.subckt sky130_fd_sc_hd__dfrtp_1 CLK D RESET_B VGND VNB VPB VPWR Q
.ends

* Black-box entry subcircuit for sky130_fd_sc_hd__inv_2 abstract view
.subckt sky130_fd_sc_hd__inv_2 A VGND VNB VPB VPWR Y
.ends

* Black-box entry subcircuit for sky130_fd_sc_hd__a22o_1 abstract view
.subckt sky130_fd_sc_hd__a22o_1 A1 A2 B1 B2 VGND VNB VPB VPWR X
.ends

* Black-box entry subcircuit for sky130_ef_sc_hd__decap_12 abstract view
.subckt sky130_ef_sc_hd__decap_12 VPWR VGND VPB VNB
.ends

* Black-box entry subcircuit for sky130_fd_sc_hd__decap_4 abstract view
.subckt sky130_fd_sc_hd__decap_4 VGND VNB VPB VPWR
.ends

* Black-box entry subcircuit for sky130_fd_sc_hd__decap_6 abstract view
.subckt sky130_fd_sc_hd__decap_6 VGND VNB VPB VPWR
.ends

* Black-box entry subcircuit for sky130_fd_sc_hd__fill_1 abstract view
.subckt sky130_fd_sc_hd__fill_1 VGND VNB VPB VPWR
.ends

* Black-box entry subcircuit for sky130_fd_sc_hd__fill_2 abstract view
.subckt sky130_fd_sc_hd__fill_2 VGND VNB VPB VPWR
.ends

* Black-box entry subcircuit for sky130_fd_sc_hd__clkbuf_4 abstract view
.subckt sky130_fd_sc_hd__clkbuf_4 A VGND VNB VPB VPWR X
.ends

* Black-box entry subcircuit for sky130_fd_sc_hd__tapvpwrvgnd_1 abstract view
.subckt sky130_fd_sc_hd__tapvpwrvgnd_1 VGND VPWR
.ends

* Black-box entry subcircuit for sky130_fd_sc_hd__o21ai_1 abstract view
.subckt sky130_fd_sc_hd__o21ai_1 A1 A2 B1 VGND VNB VPB VPWR Y
.ends

* Black-box entry subcircuit for sky130_fd_sc_hd__dfstp_2 abstract view
.subckt sky130_fd_sc_hd__dfstp_2 CLK D SET_B VGND VNB VPB VPWR Q
.ends

* Black-box entry subcircuit for sky130_fd_sc_hd__clkbuf_1 abstract view
.subckt sky130_fd_sc_hd__clkbuf_1 A VGND VNB VPB VPWR X
.ends

* Black-box entry subcircuit for sky130_fd_sc_hd__or2_1 abstract view
.subckt sky130_fd_sc_hd__or2_1 A B VGND VNB VPB VPWR X
.ends

* Black-box entry subcircuit for sky130_fd_sc_hd__decap_3 abstract view
.subckt sky130_fd_sc_hd__decap_3 VGND VNB VPB VPWR
.ends

* Black-box entry subcircuit for sky130_fd_sc_hd__decap_8 abstract view
.subckt sky130_fd_sc_hd__decap_8 VGND VNB VPB VPWR
.ends

* Black-box entry subcircuit for sky130_fd_sc_hd__buf_2 abstract view
.subckt sky130_fd_sc_hd__buf_2 A VGND VNB VPB VPWR X
.ends

* Black-box entry subcircuit for sky130_fd_sc_hd__nor3_1 abstract view
.subckt sky130_fd_sc_hd__nor3_1 A B C VGND VNB VPB VPWR Y
.ends

* Black-box entry subcircuit for sky130_fd_sc_hd__dfrtp_2 abstract view
.subckt sky130_fd_sc_hd__dfrtp_2 CLK D RESET_B VGND VNB VPB VPWR Q
.ends

* Black-box entry subcircuit for sky130_fd_sc_hd__mux2_1 abstract view
.subckt sky130_fd_sc_hd__mux2_1 A0 A1 S VGND VNB VPB VPWR X
.ends

* Black-box entry subcircuit for sky130_fd_sc_hd__o21a_1 abstract view
.subckt sky130_fd_sc_hd__o21a_1 A1 A2 B1 VGND VNB VPB VPWR X
.ends

* Black-box entry subcircuit for sky130_fd_sc_hd__nand2_1 abstract view
.subckt sky130_fd_sc_hd__nand2_1 A B VGND VNB VPB VPWR Y
.ends

* Black-box entry subcircuit for sky130_fd_sc_hd__and4bb_1 abstract view
.subckt sky130_fd_sc_hd__and4bb_1 A_N B_N C D VGND VNB VPB VPWR X
.ends

* Black-box entry subcircuit for sky130_fd_sc_hd__and3_1 abstract view
.subckt sky130_fd_sc_hd__and3_1 A B C VGND VNB VPB VPWR X
.ends

* Black-box entry subcircuit for sky130_fd_sc_hd__a31o_1 abstract view
.subckt sky130_fd_sc_hd__a31o_1 A1 A2 A3 B1 VGND VNB VPB VPWR X
.ends

* Black-box entry subcircuit for sky130_fd_sc_hd__a221o_1 abstract view
.subckt sky130_fd_sc_hd__a221o_1 A1 A2 B1 B2 C1 VGND VNB VPB VPWR X
.ends

* Black-box entry subcircuit for sky130_fd_sc_hd__a31oi_4 abstract view
.subckt sky130_fd_sc_hd__a31oi_4 A1 A2 A3 B1 VGND VNB VPB VPWR Y
.ends

* Black-box entry subcircuit for sky130_fd_sc_hd__o221a_1 abstract view
.subckt sky130_fd_sc_hd__o221a_1 A1 A2 B1 B2 C1 VGND VNB VPB VPWR X
.ends

* Black-box entry subcircuit for sky130_fd_sc_hd__a32o_1 abstract view
.subckt sky130_fd_sc_hd__a32o_1 A1 A2 A3 B1 B2 VGND VNB VPB VPWR X
.ends

* Black-box entry subcircuit for sky130_fd_sc_hd__nor2_2 abstract view
.subckt sky130_fd_sc_hd__nor2_2 A B VGND VNB VPB VPWR Y
.ends

* Black-box entry subcircuit for sky130_fd_sc_hd__and4_2 abstract view
.subckt sky130_fd_sc_hd__and4_2 A B C D VGND VNB VPB VPWR X
.ends

* Black-box entry subcircuit for sky130_fd_sc_hd__nor2_1 abstract view
.subckt sky130_fd_sc_hd__nor2_1 A B VGND VNB VPB VPWR Y
.ends

* Black-box entry subcircuit for sky130_fd_sc_hd__a21oi_2 abstract view
.subckt sky130_fd_sc_hd__a21oi_2 A1 A2 B1 VGND VNB VPB VPWR Y
.ends

* Black-box entry subcircuit for sky130_fd_sc_hd__conb_1 abstract view
.subckt sky130_fd_sc_hd__conb_1 VGND VNB VPB VPWR HI LO
.ends

* Black-box entry subcircuit for sky130_fd_sc_hd__and2b_1 abstract view
.subckt sky130_fd_sc_hd__and2b_1 A_N B VGND VNB VPB VPWR X
.ends

* Black-box entry subcircuit for sky130_fd_sc_hd__clkbuf_16 abstract view
.subckt sky130_fd_sc_hd__clkbuf_16 A VGND VNB VPB VPWR X
.ends

* Black-box entry subcircuit for sky130_fd_sc_hd__and4_1 abstract view
.subckt sky130_fd_sc_hd__and4_1 A B C D VGND VNB VPB VPWR X
.ends

* Black-box entry subcircuit for sky130_fd_sc_hd__o211a_1 abstract view
.subckt sky130_fd_sc_hd__o211a_1 A1 A2 B1 C1 VGND VNB VPB VPWR X
.ends

* Black-box entry subcircuit for sky130_fd_sc_hd__o2111a_1 abstract view
.subckt sky130_fd_sc_hd__o2111a_1 A1 A2 B1 C1 D1 VGND VNB VPB VPWR X
.ends

* Black-box entry subcircuit for sky130_fd_sc_hd__or4b_1 abstract view
.subckt sky130_fd_sc_hd__or4b_1 A B C D_N VGND VNB VPB VPWR X
.ends

* Black-box entry subcircuit for sky130_fd_sc_hd__o21ba_1 abstract view
.subckt sky130_fd_sc_hd__o21ba_1 A1 A2 B1_N VGND VNB VPB VPWR X
.ends

* Black-box entry subcircuit for sky130_fd_sc_hd__a31o_2 abstract view
.subckt sky130_fd_sc_hd__a31o_2 A1 A2 A3 B1 VGND VNB VPB VPWR X
.ends

* Black-box entry subcircuit for sky130_fd_sc_hd__nand3_1 abstract view
.subckt sky130_fd_sc_hd__nand3_1 A B C VGND VNB VPB VPWR Y
.ends

* Black-box entry subcircuit for sky130_fd_sc_hd__dfstp_1 abstract view
.subckt sky130_fd_sc_hd__dfstp_1 CLK D SET_B VGND VNB VPB VPWR Q
.ends

* Black-box entry subcircuit for sky130_fd_sc_hd__or2b_1 abstract view
.subckt sky130_fd_sc_hd__or2b_1 A B_N VGND VNB VPB VPWR X
.ends

* Black-box entry subcircuit for sky130_fd_sc_hd__clkbuf_2 abstract view
.subckt sky130_fd_sc_hd__clkbuf_2 A VGND VNB VPB VPWR X
.ends

* Black-box entry subcircuit for sky130_fd_sc_hd__buf_1 abstract view
.subckt sky130_fd_sc_hd__buf_1 A VGND VNB VPB VPWR X
.ends

* Black-box entry subcircuit for sky130_fd_sc_hd__a211oi_1 abstract view
.subckt sky130_fd_sc_hd__a211oi_1 A1 A2 B1 C1 VGND VNB VPB VPWR Y
.ends

* Black-box entry subcircuit for sky130_fd_sc_hd__and2_1 abstract view
.subckt sky130_fd_sc_hd__and2_1 A B VGND VNB VPB VPWR X
.ends

* Black-box entry subcircuit for sky130_fd_sc_hd__dlygate4sd3_1 abstract view
.subckt sky130_fd_sc_hd__dlygate4sd3_1 A VGND VNB VPB VPWR X
.ends

* Black-box entry subcircuit for sky130_fd_sc_hd__a41o_1 abstract view
.subckt sky130_fd_sc_hd__a41o_1 A1 A2 A3 A4 B1 VGND VNB VPB VPWR X
.ends

* Black-box entry subcircuit for sky130_fd_sc_hd__or3_1 abstract view
.subckt sky130_fd_sc_hd__or3_1 A B C VGND VNB VPB VPWR X
.ends

* Black-box entry subcircuit for sky130_fd_sc_hd__a21o_1 abstract view
.subckt sky130_fd_sc_hd__a21o_1 A1 A2 B1 VGND VNB VPB VPWR X
.ends

* Black-box entry subcircuit for sky130_fd_sc_hd__a2bb2o_1 abstract view
.subckt sky130_fd_sc_hd__a2bb2o_1 A1_N A2_N B1 B2 VGND VNB VPB VPWR X
.ends

* Black-box entry subcircuit for sky130_fd_sc_hd__xor2_1 abstract view
.subckt sky130_fd_sc_hd__xor2_1 A B VGND VNB VPB VPWR X
.ends

* Black-box entry subcircuit for sky130_fd_sc_hd__xnor2_1 abstract view
.subckt sky130_fd_sc_hd__xnor2_1 A B VGND VNB VPB VPWR Y
.ends

* Black-box entry subcircuit for sky130_fd_sc_hd__and3_2 abstract view
.subckt sky130_fd_sc_hd__and3_2 A B C VGND VNB VPB VPWR X
.ends

* Black-box entry subcircuit for sky130_fd_sc_hd__a21boi_1 abstract view
.subckt sky130_fd_sc_hd__a21boi_1 A1 A2 B1_N VGND VNB VPB VPWR Y
.ends

* Black-box entry subcircuit for sky130_fd_sc_hd__or3b_1 abstract view
.subckt sky130_fd_sc_hd__or3b_1 A B C_N VGND VNB VPB VPWR X
.ends

.subckt solar_energy_manager_top VGND VPWR battery_level[0] battery_level[1] clear_stats
+ clk critical_seen essential_load_enable nonessential_load_enable operating_mode[0]
+ operating_mode[1] rst_n solar_available solar_charge_enable stat_out[0] stat_out[1]
+ stat_out[2] stat_out[3] stat_out[4] stat_out[5] stat_out[6] stat_out[7] stat_sel[0]
+ stat_sel[1]
X_294_ t_crit\[2\] _136_ _137_ VGND VGND VPWR VPWR _029_ sky130_fd_sc_hd__a21oi_1
X_363_ clknet_2_2__leaf_clk core.next_mode\[1\] net23 VGND VGND VPWR VPWR net11 sky130_fd_sc_hd__dfrtp_4
X_346_ clknet_2_1__leaf_clk _031_ net22 VGND VGND VPWR VPWR t_crit\[4\] sky130_fd_sc_hd__dfrtp_1
X_277_ _106_ VGND VGND VPWR VPWR _125_ sky130_fd_sc_hd__inv_2
X_200_ t_save\[4\] _070_ _071_ t_crit\[4\] VGND VGND VPWR VPWR _072_ sky130_fd_sc_hd__a22o_1
X_329_ clknet_2_1__leaf_clk _015_ net22 VGND VGND VPWR VPWR t_norm\[4\] sky130_fd_sc_hd__dfrtp_1
XFILLER_0_0_29 VPWR VGND VPWR VGND sky130_ef_sc_hd__decap_12
XFILLER_0_0_18 VGND VGND VPWR VPWR sky130_fd_sc_hd__decap_4
XFILLER_0_9_49 VGND VGND VPWR VPWR sky130_fd_sc_hd__decap_6
XFILLER_0_19_125 VPWR VGND VPWR VGND sky130_ef_sc_hd__decap_12
XFILLER_0_24_183 VGND VGND VPWR VPWR sky130_fd_sc_hd__decap_6
XFILLER_0_16_139 VGND VGND VPWR VPWR sky130_fd_sc_hd__fill_1
XFILLER_0_26_29 VPWR VGND VPWR VGND sky130_ef_sc_hd__decap_12
XFILLER_0_15_161 VGND VGND VPWR VPWR sky130_fd_sc_hd__decap_6
XFILLER_0_16_62 VGND VGND VPWR VPWR sky130_fd_sc_hd__decap_6
XFILLER_0_12_153 VGND VGND VPWR VPWR sky130_fd_sc_hd__fill_2
Xoutput20 net20 VGND VGND VPWR VPWR stat_out[7] sky130_fd_sc_hd__clkbuf_4
XTAP_145 VGND VPWR sky130_fd_sc_hd__tapvpwrvgnd_1
XTAP_134 VGND VPWR sky130_fd_sc_hd__tapvpwrvgnd_1
XTAP_123 VGND VPWR sky130_fd_sc_hd__tapvpwrvgnd_1
XTAP_112 VGND VPWR sky130_fd_sc_hd__tapvpwrvgnd_1
XTAP_101 VGND VPWR sky130_fd_sc_hd__tapvpwrvgnd_1
X_293_ t_crit\[2\] _136_ _039_ VGND VGND VPWR VPWR _137_ sky130_fd_sc_hd__o21ai_1
X_362_ clknet_2_2__leaf_clk core.next_mode\[0\] net23 VGND VGND VPWR VPWR net10 sky130_fd_sc_hd__dfstp_2
XFILLER_0_13_52 VGND VGND VPWR VPWR sky130_fd_sc_hd__decap_4
XFILLER_0_1_131 VPWR VGND VPWR VGND sky130_ef_sc_hd__decap_12
X_345_ clknet_2_3__leaf_clk _030_ net24 VGND VGND VPWR VPWR t_crit\[3\] sky130_fd_sc_hd__dfrtp_1
X_276_ _124_ VGND VGND VPWR VPWR _024_ sky130_fd_sc_hd__clkbuf_1
XFILLER_0_4_83 VGND VGND VPWR VPWR sky130_fd_sc_hd__fill_1
X_328_ clknet_2_1__leaf_clk _014_ net22 VGND VGND VPWR VPWR t_norm\[3\] sky130_fd_sc_hd__dfrtp_1
X_259_ t_save\[1\] t_save\[0\] VGND VGND VPWR VPWR _112_ sky130_fd_sc_hd__or2_1
XFILLER_0_27_181 VGND VGND VPWR VPWR sky130_fd_sc_hd__decap_6
XFILLER_0_19_137 VPWR VGND VPWR VGND sky130_ef_sc_hd__decap_12
XFILLER_0_19_95 VPWR VGND VPWR VGND sky130_ef_sc_hd__decap_12
XFILLER_0_10_97 VGND VGND VPWR VPWR sky130_fd_sc_hd__fill_1
XFILLER_0_25_107 VGND VGND VPWR VPWR sky130_fd_sc_hd__decap_4
XFILLER_0_21_165 VGND VGND VPWR VPWR sky130_fd_sc_hd__decap_3
XFILLER_0_16_85 VGND VGND VPWR VPWR sky130_fd_sc_hd__fill_2
XFILLER_0_6_29 VPWR VGND VPWR VGND sky130_ef_sc_hd__decap_12
XFILLER_0_12_110 VGND VGND VPWR VPWR sky130_fd_sc_hd__decap_8
Xoutput8 net8 VGND VGND VPWR VPWR critical_seen sky130_fd_sc_hd__clkbuf_4
Xoutput10 net10 VGND VGND VPWR VPWR operating_mode[0] sky130_fd_sc_hd__buf_2
XFILLER_0_5_107 VGND VGND VPWR VPWR sky130_fd_sc_hd__decap_4
XFILLER_0_27_51 VGND VGND VPWR VPWR sky130_fd_sc_hd__decap_4
XTAP_135 VGND VPWR sky130_fd_sc_hd__tapvpwrvgnd_1
XTAP_124 VGND VPWR sky130_fd_sc_hd__tapvpwrvgnd_1
XTAP_113 VGND VPWR sky130_fd_sc_hd__tapvpwrvgnd_1
XTAP_102 VGND VPWR sky130_fd_sc_hd__tapvpwrvgnd_1
X_292_ _152_ _135_ _136_ VGND VGND VPWR VPWR _028_ sky130_fd_sc_hd__nor3_1
X_361_ clknet_2_3__leaf_clk net29 net25 VGND VGND VPWR VPWR sync2\[2\] sky130_fd_sc_hd__dfrtp_2
XFILLER_0_2_9 VPWR VGND VPWR VGND sky130_ef_sc_hd__decap_12
XFILLER_0_7_50 VGND VGND VPWR VPWR sky130_fd_sc_hd__decap_6
XFILLER_0_7_94 VGND VGND VPWR VPWR sky130_fd_sc_hd__decap_8
XFILLER_0_1_143 VPWR VGND VPWR VGND sky130_ef_sc_hd__decap_12
XFILLER_0_0_6 VPWR VGND VPWR VGND sky130_ef_sc_hd__decap_12
X_344_ clknet_2_3__leaf_clk _029_ net24 VGND VGND VPWR VPWR t_crit\[2\] sky130_fd_sc_hd__dfrtp_1
X_275_ _123_ t_save\[5\] _109_ VGND VGND VPWR VPWR _124_ sky130_fd_sc_hd__mux2_1
XFILLER_0_24_85 VGND VGND VPWR VPWR sky130_fd_sc_hd__decap_3
XFILLER_0_19_149 VPWR VGND VPWR VGND sky130_ef_sc_hd__decap_12
XFILLER_0_19_41 VPWR VGND VPWR VGND sky130_ef_sc_hd__decap_12
X_189_ t_crit\[1\] _059_ net7 VGND VGND VPWR VPWR _064_ sky130_fd_sc_hd__o21a_1
X_258_ t_save\[1\] t_save\[0\] VGND VGND VPWR VPWR _111_ sky130_fd_sc_hd__nand2_1
XFILLER_0_10_65 VPWR VGND VPWR VGND sky130_ef_sc_hd__decap_12
X_327_ clknet_2_0__leaf_clk _013_ net21 VGND VGND VPWR VPWR t_norm\[2\] sky130_fd_sc_hd__dfrtp_1
XFILLER_0_21_133 VPWR VGND VPWR VGND sky130_ef_sc_hd__decap_12
XFILLER_0_21_100 VGND VGND VPWR VPWR sky130_fd_sc_hd__fill_1
XFILLER_0_12_133 VGND VGND VPWR VPWR sky130_fd_sc_hd__decap_6
Xoutput11 net11 VGND VGND VPWR VPWR operating_mode[1] sky130_fd_sc_hd__clkbuf_4
XFILLER_0_9_3 VGND VGND VPWR VPWR sky130_fd_sc_hd__decap_8
Xoutput9 net9 VGND VGND VPWR VPWR nonessential_load_enable sky130_fd_sc_hd__clkbuf_4
XFILLER_0_27_85 VGND VGND VPWR VPWR sky130_fd_sc_hd__fill_2
XFILLER_0_27_41 VGND VGND VPWR VPWR sky130_fd_sc_hd__decap_4
XTAP_136 VGND VPWR sky130_fd_sc_hd__tapvpwrvgnd_1
XTAP_125 VGND VPWR sky130_fd_sc_hd__tapvpwrvgnd_1
XTAP_114 VGND VPWR sky130_fd_sc_hd__tapvpwrvgnd_1
XTAP_103 VGND VPWR sky130_fd_sc_hd__tapvpwrvgnd_1
X_360_ clknet_2_3__leaf_clk net30 net25 VGND VGND VPWR VPWR sync2\[1\] sky130_fd_sc_hd__dfrtp_1
X_291_ _132_ _129_ t_crit\[1\] t_crit\[0\] VGND VGND VPWR VPWR _136_ sky130_fd_sc_hd__and4bb_1
XFILLER_0_4_141 VPWR VGND VPWR VGND sky130_ef_sc_hd__decap_12
XFILLER_0_7_73 VGND VGND VPWR VPWR sky130_fd_sc_hd__decap_6
XFILLER_0_1_155 VPWR VGND VPWR VGND sky130_ef_sc_hd__decap_12
XFILLER_0_1_111 VGND VGND VPWR VPWR sky130_fd_sc_hd__fill_1
X_343_ clknet_2_3__leaf_clk _028_ net24 VGND VGND VPWR VPWR t_crit\[1\] sky130_fd_sc_hd__dfrtp_1
X_274_ _121_ _119_ _122_ VGND VGND VPWR VPWR _123_ sky130_fd_sc_hd__a21oi_1
XFILLER_0_4_85 VGND VGND VPWR VPWR sky130_fd_sc_hd__decap_4
XFILLER_0_19_53 VGND VGND VPWR VPWR sky130_fd_sc_hd__decap_3
X_257_ _110_ VGND VGND VPWR VPWR _019_ sky130_fd_sc_hd__clkbuf_1
XFILLER_0_10_44 VGND VGND VPWR VPWR sky130_fd_sc_hd__fill_1
XFILLER_0_10_77 VGND VGND VPWR VPWR sky130_fd_sc_hd__decap_6
X_188_ core.battery_level\[0\] _060_ _063_ VGND VGND VPWR VPWR net13 sky130_fd_sc_hd__o21a_1
X_326_ clknet_2_1__leaf_clk _012_ net21 VGND VGND VPWR VPWR t_norm\[1\] sky130_fd_sc_hd__dfrtp_1
XFILLER_0_27_161 VGND VGND VPWR VPWR sky130_fd_sc_hd__decap_3
X_309_ _044_ _082_ _147_ VGND VGND VPWR VPWR _148_ sky130_fd_sc_hd__and3_1
XFILLER_0_18_183 VGND VGND VPWR VPWR sky130_fd_sc_hd__decap_6
XFILLER_0_21_189 VGND VGND VPWR VPWR sky130_fd_sc_hd__fill_1
XFILLER_0_21_145 VPWR VGND VPWR VGND sky130_ef_sc_hd__decap_12
XFILLER_0_16_76 VGND VGND VPWR VPWR sky130_fd_sc_hd__fill_1
XFILLER_0_12_178 VGND VGND VPWR VPWR sky130_fd_sc_hd__decap_8
XFILLER_0_8_139 VGND VGND VPWR VPWR sky130_fd_sc_hd__fill_1
Xoutput12 net12 VGND VGND VPWR VPWR solar_charge_enable sky130_fd_sc_hd__clkbuf_4
XTAP_137 VGND VPWR sky130_fd_sc_hd__tapvpwrvgnd_1
XTAP_126 VGND VPWR sky130_fd_sc_hd__tapvpwrvgnd_1
XTAP_115 VGND VPWR sky130_fd_sc_hd__tapvpwrvgnd_1
XTAP_104 VGND VPWR sky130_fd_sc_hd__tapvpwrvgnd_1
XFILLER_0_4_153 VGND VGND VPWR VPWR sky130_fd_sc_hd__decap_4
X_290_ t_crit\[0\] _133_ t_crit\[1\] VGND VGND VPWR VPWR _135_ sky130_fd_sc_hd__a21oi_1
XFILLER_0_1_189 VGND VGND VPWR VPWR sky130_fd_sc_hd__fill_1
XFILLER_0_1_167 VGND VGND VPWR VPWR sky130_fd_sc_hd__fill_1
X_342_ clknet_2_3__leaf_clk _027_ net24 VGND VGND VPWR VPWR t_crit\[0\] sky130_fd_sc_hd__dfrtp_2
X_273_ t_save\[4\] t_save\[5\] _105_ net3 VGND VGND VPWR VPWR _122_ sky130_fd_sc_hd__a31o_1
XFILLER_0_4_42 VGND VGND VPWR VPWR sky130_fd_sc_hd__fill_2
XFILLER_0_4_75 VGND VGND VPWR VPWR sky130_fd_sc_hd__decap_8
XFILLER_0_4_97 VGND VGND VPWR VPWR sky130_fd_sc_hd__decap_6
X_325_ clknet_2_0__leaf_clk _011_ net21 VGND VGND VPWR VPWR t_norm\[0\] sky130_fd_sc_hd__dfrtp_2
X_256_ _108_ _109_ t_save\[0\] VGND VGND VPWR VPWR _110_ sky130_fd_sc_hd__mux2_1
X_187_ t_save\[0\] _059_ _061_ t_norm\[0\] _062_ VGND VGND VPWR VPWR _063_ sky130_fd_sc_hd__a221o_1
XFILLER_0_19_107 VGND VGND VPWR VPWR sky130_fd_sc_hd__decap_4
XFILLER_0_24_121 VPWR VGND VPWR VGND sky130_ef_sc_hd__decap_12
XFILLER_0_21_44 VPWR VGND VPWR VGND sky130_ef_sc_hd__decap_12
X_308_ t_crit\[6\] _130_ _131_ VGND VGND VPWR VPWR _147_ sky130_fd_sc_hd__and3_1
X_239_ t_norm\[4\] _084_ VGND VGND VPWR VPWR _097_ sky130_fd_sc_hd__nand2_1
XFILLER_0_21_157 VGND VGND VPWR VPWR sky130_fd_sc_hd__decap_8
XFILLER_0_25_3 VPWR VGND VPWR VGND sky130_ef_sc_hd__decap_12
Xoutput13 net13 VGND VGND VPWR VPWR stat_out[0] sky130_fd_sc_hd__clkbuf_4
XTAP_138 VGND VPWR sky130_fd_sc_hd__tapvpwrvgnd_1
XTAP_127 VGND VPWR sky130_fd_sc_hd__tapvpwrvgnd_1
XTAP_116 VGND VPWR sky130_fd_sc_hd__tapvpwrvgnd_1
XTAP_105 VGND VPWR sky130_fd_sc_hd__tapvpwrvgnd_1
X_272_ t_save\[5\] VGND VGND VPWR VPWR _121_ sky130_fd_sc_hd__inv_2
X_341_ clknet_2_2__leaf_clk core.solar_charge_enable net22 VGND VGND VPWR VPWR net12
+ sky130_fd_sc_hd__dfrtp_1
X_324_ clknet_2_1__leaf_clk _010_ net22 VGND VGND VPWR VPWR net8 sky130_fd_sc_hd__dfrtp_1
X_186_ t_crit\[0\] _059_ net7 VGND VGND VPWR VPWR _062_ sky130_fd_sc_hd__o21a_1
X_255_ net10 _044_ _107_ net3 VGND VGND VPWR VPWR _109_ sky130_fd_sc_hd__a31oi_4
XFILLER_0_27_141 VPWR VGND VPWR VGND sky130_ef_sc_hd__decap_12
XFILLER_0_19_88 VGND VGND VPWR VPWR sky130_fd_sc_hd__fill_1
XFILLER_0_18_141 VPWR VGND VPWR VGND sky130_ef_sc_hd__decap_12
X_307_ _145_ _144_ _146_ VGND VGND VPWR VPWR _033_ sky130_fd_sc_hd__o21a_1
XFILLER_0_24_133 VGND VGND VPWR VPWR sky130_fd_sc_hd__decap_6
X_169_ prev\[1\] VGND VGND VPWR VPWR _047_ sky130_fd_sc_hd__inv_2
X_238_ _095_ _093_ _096_ t_norm\[3\] _039_ VGND VGND VPWR VPWR _014_ sky130_fd_sc_hd__o221a_1
XFILLER_0_21_169 VPWR VGND VPWR VGND sky130_ef_sc_hd__decap_12
XFILLER_0_18_3 VGND VGND VPWR VPWR sky130_fd_sc_hd__decap_4
XFILLER_0_7_152 VGND VGND VPWR VPWR sky130_fd_sc_hd__fill_1
Xoutput14 net14 VGND VGND VPWR VPWR stat_out[1] sky130_fd_sc_hd__clkbuf_4
XTAP_139 VGND VPWR sky130_fd_sc_hd__tapvpwrvgnd_1
XFILLER_0_27_55 VGND VGND VPWR VPWR sky130_fd_sc_hd__fill_1
XTAP_128 VGND VPWR sky130_fd_sc_hd__tapvpwrvgnd_1
XTAP_117 VGND VPWR sky130_fd_sc_hd__tapvpwrvgnd_1
XTAP_106 VGND VPWR sky130_fd_sc_hd__tapvpwrvgnd_1
XPHY_0 VGND VGND VPWR VPWR sky130_fd_sc_hd__decap_3
XFILLER_0_7_65 VGND VGND VPWR VPWR sky130_fd_sc_hd__fill_2
XFILLER_0_7_3 VGND VGND VPWR VPWR sky130_fd_sc_hd__decap_8
XFILLER_0_13_57 VPWR VGND VPWR VGND sky130_ef_sc_hd__decap_12
XFILLER_0_1_169 VPWR VGND VPWR VGND sky130_ef_sc_hd__decap_12
XFILLER_0_1_103 VGND VGND VPWR VPWR sky130_fd_sc_hd__decap_8
X_271_ _119_ _108_ _120_ _109_ t_save\[4\] VGND VGND VPWR VPWR _023_ sky130_fd_sc_hd__a32o_1
X_340_ clknet_2_0__leaf_clk _026_ net21 VGND VGND VPWR VPWR t_save\[7\] sky130_fd_sc_hd__dfrtp_1
X_185_ net6 net7 VGND VGND VPWR VPWR _061_ sky130_fd_sc_hd__nor2_2
X_323_ clknet_2_0__leaf_clk _006_ net21 VGND VGND VPWR VPWR presc\[3\] sky130_fd_sc_hd__dfrtp_1
X_254_ net10 _038_ _044_ _107_ VGND VGND VPWR VPWR _108_ sky130_fd_sc_hd__and4_2
XFILLER_0_27_153 VGND VGND VPWR VPWR sky130_fd_sc_hd__decap_8
XFILLER_0_18_153 VGND VGND VPWR VPWR sky130_fd_sc_hd__decap_4
XFILLER_0_24_189 VGND VGND VPWR VPWR sky130_fd_sc_hd__fill_1
XFILLER_0_24_145 VGND VGND VPWR VPWR sky130_fd_sc_hd__fill_1
X_306_ _145_ _144_ _152_ VGND VGND VPWR VPWR _146_ sky130_fd_sc_hd__a21oi_1
XFILLER_0_21_57 VPWR VGND VPWR VGND sky130_ef_sc_hd__decap_12
XFILLER_0_21_35 VGND VGND VPWR VPWR sky130_fd_sc_hd__decap_3
X_168_ sync2\[0\] VGND VGND VPWR VPWR _046_ sky130_fd_sc_hd__inv_2
X_237_ _092_ _093_ VGND VGND VPWR VPWR _096_ sky130_fd_sc_hd__nor2_1
XFILLER_0_15_167 VGND VGND VPWR VPWR sky130_fd_sc_hd__fill_1
XFILLER_0_16_68 VGND VGND VPWR VPWR sky130_fd_sc_hd__fill_1
Xoutput15 net15 VGND VGND VPWR VPWR stat_out[2] sky130_fd_sc_hd__clkbuf_4
XFILLER_0_7_175 VPWR VGND VPWR VGND sky130_ef_sc_hd__decap_12
XTAP_129 VGND VPWR sky130_fd_sc_hd__tapvpwrvgnd_1
XTAP_118 VGND VPWR sky130_fd_sc_hd__tapvpwrvgnd_1
XTAP_107 VGND VPWR sky130_fd_sc_hd__tapvpwrvgnd_1
XPHY_1 VGND VGND VPWR VPWR sky130_fd_sc_hd__decap_3
XFILLER_0_7_11 VGND VGND VPWR VPWR sky130_fd_sc_hd__decap_3
XFILLER_0_4_189 VGND VGND VPWR VPWR sky130_fd_sc_hd__fill_1
XFILLER_0_13_69 VPWR VGND VPWR VGND sky130_ef_sc_hd__decap_12
X_270_ t_save\[4\] _105_ VGND VGND VPWR VPWR _120_ sky130_fd_sc_hd__or2_1
X_322_ clknet_2_0__leaf_clk _005_ net21 VGND VGND VPWR VPWR presc\[2\] sky130_fd_sc_hd__dfrtp_1
XFILLER_0_27_121 VGND VGND VPWR VPWR sky130_fd_sc_hd__fill_1
XFILLER_0_27_110 VGND VGND VPWR VPWR sky130_fd_sc_hd__fill_2
XFILLER_0_19_68 VPWR VGND VPWR VGND sky130_ef_sc_hd__decap_12
X_184_ _059_ net7 VGND VGND VPWR VPWR _060_ sky130_fd_sc_hd__nand2_1
X_253_ t_save\[7\] _106_ net11 VGND VGND VPWR VPWR _107_ sky130_fd_sc_hd__a21oi_2
X_305_ t_crit\[6\] VGND VGND VPWR VPWR _145_ sky130_fd_sc_hd__inv_2
XFILLER_0_21_69 VGND VGND VPWR VPWR sky130_fd_sc_hd__fill_1
X_236_ _094_ _092_ VGND VGND VPWR VPWR _095_ sky130_fd_sc_hd__or2_1
X_167_ net33 _041_ _045_ VGND VGND VPWR VPWR _006_ sky130_fd_sc_hd__o21a_1
XFILLER_0_27_9 VGND VGND VPWR VPWR sky130_fd_sc_hd__fill_1
XFILLER_0_15_113 VPWR VGND VPWR VGND sky130_ef_sc_hd__decap_12
XFILLER_0_1_35 VGND VGND VPWR VPWR sky130_fd_sc_hd__fill_1
X_355__27 VGND VGND VPWR VPWR _355__27/HI net27 sky130_fd_sc_hd__conb_1
X_219_ net10 net11 VGND VGND VPWR VPWR _082_ sky130_fd_sc_hd__and2b_1
Xoutput16 net16 VGND VGND VPWR VPWR stat_out[3] sky130_fd_sc_hd__clkbuf_4
XFILLER_0_7_187 VGND VGND VPWR VPWR sky130_fd_sc_hd__decap_3
XFILLER_0_27_57 VPWR VGND VPWR VGND sky130_ef_sc_hd__decap_12
XFILLER_0_27_13 VPWR VGND VPWR VGND sky130_ef_sc_hd__decap_12
XTAP_119 VGND VPWR sky130_fd_sc_hd__tapvpwrvgnd_1
XTAP_108 VGND VPWR sky130_fd_sc_hd__tapvpwrvgnd_1
Xclkbuf_0_clk clk VGND VGND VPWR VPWR clknet_0_clk sky130_fd_sc_hd__clkbuf_16
XPHY_2 VGND VGND VPWR VPWR sky130_fd_sc_hd__decap_3
XFILLER_0_23_3 VPWR VGND VPWR VGND sky130_ef_sc_hd__decap_12
XFILLER_0_4_124 VPWR VGND VPWR VGND sky130_ef_sc_hd__decap_12
XFILLER_0_13_15 VPWR VGND VPWR VGND sky130_ef_sc_hd__decap_12
X_252_ t_save\[4\] t_save\[5\] t_save\[6\] _105_ VGND VGND VPWR VPWR _106_ sky130_fd_sc_hd__and4_1
X_183_ net6 VGND VGND VPWR VPWR _059_ sky130_fd_sc_hd__buf_2
X_321_ clknet_2_0__leaf_clk _004_ net21 VGND VGND VPWR VPWR presc\[1\] sky130_fd_sc_hd__dfrtp_1
XFILLER_0_18_133 VGND VGND VPWR VPWR sky130_fd_sc_hd__decap_6
X_304_ t_crit\[5\] _143_ _144_ _039_ VGND VGND VPWR VPWR _032_ sky130_fd_sc_hd__o211a_1
XFILLER_0_21_15 VPWR VGND VPWR VGND sky130_ef_sc_hd__decap_12
X_235_ t_norm\[3\] VGND VGND VPWR VPWR _094_ sky130_fd_sc_hd__inv_2
XFILLER_0_15_169 VGND VGND VPWR VPWR sky130_fd_sc_hd__fill_1
XFILLER_0_1_69 VPWR VGND VPWR VGND sky130_ef_sc_hd__decap_12
X_166_ _152_ _044_ VGND VGND VPWR VPWR _045_ sky130_fd_sc_hd__nor2_1
XFILLER_0_11_92 VPWR VGND VPWR VGND sky130_ef_sc_hd__decap_12
XFILLER_0_16_15 VGND VGND VPWR VPWR sky130_fd_sc_hd__fill_1
XFILLER_0_12_139 VGND VGND VPWR VPWR sky130_fd_sc_hd__fill_1
X_218_ _081_ VGND VGND VPWR VPWR _009_ sky130_fd_sc_hd__clkbuf_1
Xoutput17 net17 VGND VGND VPWR VPWR stat_out[4] sky130_fd_sc_hd__clkbuf_4
XFILLER_0_11_150 VGND VGND VPWR VPWR sky130_fd_sc_hd__decap_4
XFILLER_0_27_69 VPWR VGND VPWR VGND sky130_ef_sc_hd__decap_12
XFILLER_0_27_25 VGND VGND VPWR VPWR sky130_fd_sc_hd__decap_3
XTAP_109 VGND VPWR sky130_fd_sc_hd__tapvpwrvgnd_1
XPHY_3 VGND VGND VPWR VPWR sky130_fd_sc_hd__decap_3
XFILLER_0_4_136 VGND VGND VPWR VPWR sky130_fd_sc_hd__decap_4
XFILLER_0_7_57 VGND VGND VPWR VPWR sky130_fd_sc_hd__decap_8
XFILLER_0_13_27 VPWR VGND VPWR VGND sky130_ef_sc_hd__decap_12
XFILLER_0_0_161 VGND VGND VPWR VPWR sky130_fd_sc_hd__decap_6
XFILLER_0_24_37 VGND VGND VPWR VPWR sky130_fd_sc_hd__fill_1
XFILLER_0_24_26 VGND VGND VPWR VPWR sky130_fd_sc_hd__fill_2
XFILLER_0_5_3 VPWR VGND VPWR VGND sky130_ef_sc_hd__decap_12
Xclkbuf_2_0__f_clk clknet_0_clk VGND VGND VPWR VPWR clknet_2_0__leaf_clk sky130_fd_sc_hd__clkbuf_16
XFILLER_0_19_15 VGND VGND VPWR VPWR sky130_fd_sc_hd__decap_8
X_320_ clknet_2_0__leaf_clk _003_ net21 VGND VGND VPWR VPWR presc\[0\] sky130_fd_sc_hd__dfrtp_2
X_182_ dcnt\[1\] dcnt\[0\] _052_ _056_ _058_ VGND VGND VPWR VPWR _001_ sky130_fd_sc_hd__o2111a_1
X_251_ t_save\[1\] t_save\[0\] t_save\[3\] t_save\[2\] VGND VGND VPWR VPWR _105_ sky130_fd_sc_hd__and4_2
XFILLER_0_27_167 VGND VGND VPWR VPWR sky130_fd_sc_hd__fill_1
XFILLER_0_18_189 VGND VGND VPWR VPWR sky130_fd_sc_hd__fill_1
X_303_ _129_ _132_ _142_ t_crit\[5\] VGND VGND VPWR VPWR _144_ sky130_fd_sc_hd__or4b_1
XFILLER_0_21_27 VGND VGND VPWR VPWR sky130_fd_sc_hd__decap_8
X_234_ _092_ _093_ _091_ t_norm\[2\] _039_ VGND VGND VPWR VPWR _013_ sky130_fd_sc_hd__o221a_1
XFILLER_0_1_15 VPWR VGND VPWR VGND sky130_ef_sc_hd__decap_12
X_165_ _043_ VGND VGND VPWR VPWR _044_ sky130_fd_sc_hd__clkbuf_4
XFILLER_0_16_38 VPWR VGND VPWR VGND sky130_ef_sc_hd__decap_12
X_217_ sync2\[2\] core.solar_available _078_ VGND VGND VPWR VPWR _081_ sky130_fd_sc_hd__mux2_1
Xoutput18 net18 VGND VGND VPWR VPWR stat_out[5] sky130_fd_sc_hd__clkbuf_4
XFILLER_0_22_92 VGND VGND VPWR VPWR sky130_fd_sc_hd__decap_3
XFILLER_0_18_7 VGND VGND VPWR VPWR sky130_fd_sc_hd__fill_1
XFILLER_0_7_134 VPWR VGND VPWR VGND sky130_ef_sc_hd__decap_12
XFILLER_0_7_156 VPWR VGND VPWR VGND sky130_ef_sc_hd__decap_12
XPHY_4 VGND VGND VPWR VPWR sky130_fd_sc_hd__decap_3
XFILLER_0_3_181 VGND VGND VPWR VPWR sky130_fd_sc_hd__decap_8
XFILLER_0_0_184 VGND VGND VPWR VPWR sky130_fd_sc_hd__fill_2
XFILLER_0_4_15 VPWR VGND VPWR VGND sky130_ef_sc_hd__decap_12
X_181_ dcnt\[1\] dcnt\[0\] dcnt\[2\] VGND VGND VPWR VPWR _058_ sky130_fd_sc_hd__a21oi_1
X_250_ _104_ VGND VGND VPWR VPWR _018_ sky130_fd_sc_hd__clkbuf_1
XFILLER_0_10_29 VGND VGND VPWR VPWR sky130_fd_sc_hd__fill_1
XFILLER_0_27_113 VGND VGND VPWR VPWR sky130_fd_sc_hd__decap_8
XFILLER_0_27_102 VGND VGND VPWR VPWR sky130_fd_sc_hd__decap_8
XFILLER_0_18_124 VGND VGND VPWR VPWR sky130_fd_sc_hd__decap_3
X_302_ _152_ _133_ _142_ VGND VGND VPWR VPWR _143_ sky130_fd_sc_hd__o21ba_1
XFILLER_0_1_27 VGND VGND VPWR VPWR sky130_fd_sc_hd__decap_8
X_164_ presc\[2\] presc\[3\] presc\[1\] presc\[0\] VGND VGND VPWR VPWR _043_ sky130_fd_sc_hd__and4_1
X_233_ t_norm\[6\] t_norm\[7\] _085_ _086_ VGND VGND VPWR VPWR _093_ sky130_fd_sc_hd__a31o_2
XFILLER_0_15_149 VPWR VGND VPWR VGND sky130_ef_sc_hd__decap_12
XFILLER_0_11_83 VGND VGND VPWR VPWR sky130_fd_sc_hd__fill_1
XFILLER_0_21_108 VGND VGND VPWR VPWR sky130_fd_sc_hd__decap_4
XFILLER_0_22_82 VGND VGND VPWR VPWR sky130_fd_sc_hd__fill_2
XFILLER_0_20_141 VPWR VGND VPWR VGND sky130_ef_sc_hd__decap_12
XFILLER_0_7_102 VGND VGND VPWR VPWR sky130_fd_sc_hd__fill_1
XFILLER_0_7_146 VGND VGND VPWR VPWR sky130_fd_sc_hd__decap_6
X_216_ _080_ VGND VGND VPWR VPWR _008_ sky130_fd_sc_hd__clkbuf_1
Xoutput19 net19 VGND VGND VPWR VPWR stat_out[6] sky130_fd_sc_hd__clkbuf_4
XPHY_5 VGND VGND VPWR VPWR sky130_fd_sc_hd__decap_3
XFILLER_0_1_119 VPWR VGND VPWR VGND sky130_ef_sc_hd__decap_12
XFILLER_0_21_3 VPWR VGND VPWR VGND sky130_ef_sc_hd__decap_12
XFILLER_0_0_141 VGND VGND VPWR VPWR sky130_fd_sc_hd__fill_2
XFILLER_0_8_80 VGND VGND VPWR VPWR sky130_fd_sc_hd__decap_4
XFILLER_0_4_27 VGND VGND VPWR VPWR sky130_fd_sc_hd__fill_1
Xfanout21 net22 VGND VGND VPWR VPWR net21 sky130_fd_sc_hd__clkbuf_4
X_180_ _057_ VGND VGND VPWR VPWR _000_ sky130_fd_sc_hd__clkbuf_1
XFILLER_0_27_169 VPWR VGND VPWR VGND sky130_ef_sc_hd__decap_12
XFILLER_0_24_139 VGND VGND VPWR VPWR sky130_fd_sc_hd__fill_1
X_301_ t_crit\[4\] _130_ VGND VGND VPWR VPWR _142_ sky130_fd_sc_hd__nand2_1
X_232_ t_norm\[1\] t_norm\[0\] t_norm\[2\] VGND VGND VPWR VPWR _092_ sky130_fd_sc_hd__nand3_1
X_163_ _152_ _041_ _042_ VGND VGND VPWR VPWR _005_ sky130_fd_sc_hd__nor3_1
XFILLER_0_15_128 VGND VGND VPWR VPWR sky130_fd_sc_hd__fill_1
XFILLER_0_15_106 VGND VGND VPWR VPWR sky130_fd_sc_hd__decap_6
XFILLER_0_14_172 VPWR VGND VPWR VGND sky130_ef_sc_hd__decap_12
XFILLER_0_20_153 VPWR VGND VPWR VGND sky130_ef_sc_hd__decap_12
X_215_ sync2\[1\] core.battery_level\[1\] _078_ VGND VGND VPWR VPWR _080_ sky130_fd_sc_hd__mux2_1
XFILLER_0_11_186 VGND VGND VPWR VPWR sky130_fd_sc_hd__decap_4
XPHY_6 VGND VGND VPWR VPWR sky130_fd_sc_hd__decap_3
XFILLER_0_7_38 VPWR VGND VPWR VGND sky130_ef_sc_hd__decap_12
XFILLER_0_14_3 VPWR VGND VPWR VGND sky130_ef_sc_hd__decap_12
XFILLER_0_24_29 VGND VGND VPWR VPWR sky130_fd_sc_hd__decap_8
XFILLER_0_24_18 VGND VGND VPWR VPWR sky130_fd_sc_hd__decap_8
Xfanout22 net4 VGND VGND VPWR VPWR net22 sky130_fd_sc_hd__clkbuf_4
XFILLER_0_19_29 VPWR VGND VPWR VGND sky130_ef_sc_hd__decap_12
XFILLER_0_3_3 VPWR VGND VPWR VGND sky130_ef_sc_hd__decap_12
XFILLER_0_18_104 VPWR VGND VPWR VGND sky130_ef_sc_hd__decap_12
X_300_ _140_ _139_ _141_ VGND VGND VPWR VPWR _031_ sky130_fd_sc_hd__o21ba_1
X_162_ presc\[1\] presc\[0\] presc\[2\] VGND VGND VPWR VPWR _042_ sky130_fd_sc_hd__a21oi_1
X_231_ _152_ _090_ _091_ VGND VGND VPWR VPWR _012_ sky130_fd_sc_hd__nor3_1
Xinput1 battery_level[0] VGND VGND VPWR VPWR net1 sky130_fd_sc_hd__clkbuf_1
XFILLER_0_14_184 VGND VGND VPWR VPWR sky130_fd_sc_hd__decap_6
XTAP_90 VGND VPWR sky130_fd_sc_hd__tapvpwrvgnd_1
XFILLER_0_20_165 VPWR VGND VPWR VGND sky130_ef_sc_hd__decap_12
XFILLER_0_20_121 VPWR VGND VPWR VGND sky130_ef_sc_hd__decap_12
X_214_ _079_ VGND VGND VPWR VPWR _007_ sky130_fd_sc_hd__clkbuf_1
XFILLER_0_27_29 VPWR VGND VPWR VGND sky130_ef_sc_hd__decap_12
XPHY_7 VGND VGND VPWR VPWR sky130_fd_sc_hd__decap_3
XFILLER_0_4_29 VGND VGND VPWR VPWR sky130_fd_sc_hd__fill_2
XFILLER_0_14_85 VGND VGND VPWR VPWR sky130_fd_sc_hd__fill_2
Xfanout23 net26 VGND VGND VPWR VPWR net23 sky130_fd_sc_hd__clkbuf_4
XFILLER_0_25_51 VGND VGND VPWR VPWR sky130_fd_sc_hd__decap_4
XFILLER_0_18_116 VGND VGND VPWR VPWR sky130_fd_sc_hd__decap_8
X_161_ presc\[2\] presc\[1\] presc\[0\] VGND VGND VPWR VPWR _041_ sky130_fd_sc_hd__and3_1
X_230_ t_norm\[1\] t_norm\[0\] _087_ VGND VGND VPWR VPWR _091_ sky130_fd_sc_hd__and3_1
X_359_ clknet_2_3__leaf_clk net31 net25 VGND VGND VPWR VPWR sync2\[0\] sky130_fd_sc_hd__dfstp_1
Xinput2 battery_level[1] VGND VGND VPWR VPWR net2 sky130_fd_sc_hd__clkbuf_1
XFILLER_0_14_141 VPWR VGND VPWR VGND sky130_ef_sc_hd__decap_12
XTAP_80 VGND VPWR sky130_fd_sc_hd__tapvpwrvgnd_1
XTAP_91 VGND VPWR sky130_fd_sc_hd__tapvpwrvgnd_1
XFILLER_0_20_177 VPWR VGND VPWR VGND sky130_ef_sc_hd__decap_12
XFILLER_0_20_133 VGND VGND VPWR VPWR sky130_fd_sc_hd__decap_6
X_213_ sync2\[0\] core.battery_level\[0\] _078_ VGND VGND VPWR VPWR _079_ sky130_fd_sc_hd__mux2_1
XPHY_8 VGND VGND VPWR VPWR sky130_fd_sc_hd__decap_3
Xsolar_energy_manager_top_28 VGND VGND VPWR VPWR essential_load_enable solar_energy_manager_top_28/LO
+ sky130_fd_sc_hd__conb_1
XFILLER_0_0_177 VGND VGND VPWR VPWR sky130_fd_sc_hd__fill_1
XFILLER_0_0_111 VGND VGND VPWR VPWR sky130_fd_sc_hd__fill_1
XFILLER_0_8_61 VGND VGND VPWR VPWR sky130_fd_sc_hd__decap_8
Xfanout24 net26 VGND VGND VPWR VPWR net24 sky130_fd_sc_hd__clkbuf_4
XFILLER_0_27_128 VPWR VGND VPWR VGND sky130_ef_sc_hd__decap_12
XFILLER_0_25_63 VGND VGND VPWR VPWR sky130_fd_sc_hd__decap_3
XFILLER_0_18_139 VGND VGND VPWR VPWR sky130_fd_sc_hd__fill_1
X_358_ clknet_2_3__leaf_clk net5 net25 VGND VGND VPWR VPWR sync1\[2\] sky130_fd_sc_hd__dfrtp_1
X_160_ presc\[1\] presc\[0\] _040_ VGND VGND VPWR VPWR _004_ sky130_fd_sc_hd__a21oi_1
Xinput3 clear_stats VGND VGND VPWR VPWR net3 sky130_fd_sc_hd__clkbuf_4
X_289_ t_crit\[0\] _133_ _134_ VGND VGND VPWR VPWR _027_ sky130_fd_sc_hd__o21a_1
XTAP_70 VGND VPWR sky130_fd_sc_hd__tapvpwrvgnd_1
XTAP_81 VGND VPWR sky130_fd_sc_hd__tapvpwrvgnd_1
XTAP_92 VGND VPWR sky130_fd_sc_hd__tapvpwrvgnd_1
XFILLER_0_14_153 VPWR VGND VPWR VGND sky130_ef_sc_hd__decap_12
X_212_ _058_ _052_ VGND VGND VPWR VPWR _078_ sky130_fd_sc_hd__or2b_1
XFILLER_0_20_189 VGND VGND VPWR VPWR sky130_fd_sc_hd__fill_1
XFILLER_0_2_85 VGND VGND VPWR VPWR sky130_fd_sc_hd__decap_4
XFILLER_0_6_161 VGND VGND VPWR VPWR sky130_fd_sc_hd__fill_2
XPHY_9 VGND VGND VPWR VPWR sky130_fd_sc_hd__decap_3
XFILLER_0_16_9 VGND VGND VPWR VPWR sky130_fd_sc_hd__decap_6
XFILLER_0_3_164 VGND VGND VPWR VPWR sky130_fd_sc_hd__decap_4
XFILLER_0_0_167 VGND VGND VPWR VPWR sky130_fd_sc_hd__fill_1
XFILLER_0_14_98 VGND VGND VPWR VPWR sky130_fd_sc_hd__fill_1
XFILLER_0_14_65 VPWR VGND VPWR VGND sky130_ef_sc_hd__decap_12
Xfanout25 net26 VGND VGND VPWR VPWR net25 sky130_fd_sc_hd__clkbuf_2
XFILLER_0_12_3 VPWR VGND VPWR VGND sky130_ef_sc_hd__decap_12
XFILLER_0_26_173 VGND VGND VPWR VPWR sky130_fd_sc_hd__decap_3
XFILLER_0_5_41 VGND VGND VPWR VPWR sky130_fd_sc_hd__decap_8
XFILLER_0_1_3 VPWR VGND VPWR VGND sky130_ef_sc_hd__decap_12
X_357_ clknet_2_3__leaf_clk net2 net25 VGND VGND VPWR VPWR sync1\[1\] sky130_fd_sc_hd__dfrtp_1
X_288_ t_crit\[0\] _133_ _152_ VGND VGND VPWR VPWR _134_ sky130_fd_sc_hd__a21oi_1
XFILLER_0_23_110 VGND VGND VPWR VPWR sky130_fd_sc_hd__fill_2
Xclkbuf_2_1__f_clk clknet_0_clk VGND VGND VPWR VPWR clknet_2_1__leaf_clk sky130_fd_sc_hd__clkbuf_16
XTAP_60 VGND VPWR sky130_fd_sc_hd__tapvpwrvgnd_1
Xinput4 rst_n VGND VGND VPWR VPWR net4 sky130_fd_sc_hd__buf_1
XTAP_71 VGND VPWR sky130_fd_sc_hd__tapvpwrvgnd_1
XTAP_82 VGND VPWR sky130_fd_sc_hd__tapvpwrvgnd_1
XFILLER_0_11_55 VGND VGND VPWR VPWR sky130_fd_sc_hd__fill_1
XFILLER_0_11_77 VGND VGND VPWR VPWR sky130_fd_sc_hd__decap_6
XTAP_93 VGND VPWR sky130_fd_sc_hd__tapvpwrvgnd_1
XFILLER_0_14_165 VGND VGND VPWR VPWR sky130_fd_sc_hd__decap_4
X_211_ net11 net10 core.battery_level\[0\] core.battery_level\[1\] VGND VGND VPWR
+ VPWR core.next_mode\[1\] sky130_fd_sc_hd__a211oi_1
XFILLER_0_2_64 VPWR VGND VPWR VGND sky130_ef_sc_hd__decap_12
XFILLER_0_11_113 VGND VGND VPWR VPWR sky130_fd_sc_hd__fill_2
XFILLER_0_17_87 VGND VGND VPWR VPWR sky130_fd_sc_hd__fill_1
XFILLER_0_0_113 VPWR VGND VPWR VGND sky130_ef_sc_hd__decap_12
XFILLER_0_14_77 VGND VGND VPWR VPWR sky130_fd_sc_hd__fill_1
Xfanout26 net4 VGND VGND VPWR VPWR net26 sky130_fd_sc_hd__clkbuf_2
XFILLER_0_26_141 VPWR VGND VPWR VGND sky130_ef_sc_hd__decap_12
XFILLER_0_5_53 VGND VGND VPWR VPWR sky130_fd_sc_hd__decap_3
Xinput5 solar_available VGND VGND VPWR VPWR net5 sky130_fd_sc_hd__clkbuf_1
X_356_ clknet_2_3__leaf_clk net1 net25 VGND VGND VPWR VPWR sync1\[0\] sky130_fd_sc_hd__dfstp_1
XFILLER_0_23_166 VGND VGND VPWR VPWR sky130_fd_sc_hd__fill_2
XFILLER_0_23_133 VPWR VGND VPWR VGND sky130_ef_sc_hd__decap_12
X_287_ _129_ _132_ VGND VGND VPWR VPWR _133_ sky130_fd_sc_hd__nor2_2
XFILLER_0_11_23 VGND VGND VPWR VPWR sky130_fd_sc_hd__fill_1
XTAP_61 VGND VPWR sky130_fd_sc_hd__tapvpwrvgnd_1
XTAP_72 VGND VPWR sky130_fd_sc_hd__tapvpwrvgnd_1
XTAP_83 VGND VPWR sky130_fd_sc_hd__tapvpwrvgnd_1
XTAP_94 VGND VPWR sky130_fd_sc_hd__tapvpwrvgnd_1
X_210_ net11 net10 core.battery_level\[0\] _077_ VGND VGND VPWR VPWR core.next_mode\[0\]
+ sky130_fd_sc_hd__a22o_1
X_339_ clknet_2_1__leaf_clk _025_ net24 VGND VGND VPWR VPWR t_save\[6\] sky130_fd_sc_hd__dfrtp_1
XFILLER_0_2_76 VGND VGND VPWR VPWR sky130_fd_sc_hd__decap_8
XFILLER_0_2_21 VGND VGND VPWR VPWR sky130_fd_sc_hd__decap_6
XFILLER_0_6_141 VPWR VGND VPWR VGND sky130_ef_sc_hd__decap_12
XFILLER_0_3_111 VGND VGND VPWR VPWR sky130_fd_sc_hd__fill_1
XFILLER_0_0_169 VGND VGND VPWR VPWR sky130_fd_sc_hd__decap_8
XFILLER_0_0_125 VPWR VGND VPWR VGND sky130_ef_sc_hd__decap_12
XFILLER_0_14_23 VGND VGND VPWR VPWR sky130_fd_sc_hd__fill_2
XFILLER_0_26_153 VPWR VGND VPWR VGND sky130_ef_sc_hd__decap_12
XFILLER_0_25_77 VPWR VGND VPWR VGND sky130_ef_sc_hd__decap_12
XFILLER_0_25_55 VGND VGND VPWR VPWR sky130_fd_sc_hd__fill_1
XFILLER_0_5_65 VGND VGND VPWR VPWR sky130_fd_sc_hd__fill_2
XFILLER_0_5_87 VPWR VGND VPWR VGND sky130_ef_sc_hd__decap_12
XFILLER_0_23_145 VGND VGND VPWR VPWR sky130_fd_sc_hd__fill_1
X_286_ t_crit\[7\] t_crit\[6\] _130_ _131_ VGND VGND VPWR VPWR _132_ sky130_fd_sc_hd__and4_1
X_355_ clknet_2_2__leaf_clk net27 net26 VGND VGND VPWR VPWR dcnt\[2\] sky130_fd_sc_hd__dfrtp_1
Xinput6 stat_sel[0] VGND VGND VPWR VPWR net6 sky130_fd_sc_hd__buf_1
XTAP_62 VGND VPWR sky130_fd_sc_hd__tapvpwrvgnd_1
XTAP_73 VGND VPWR sky130_fd_sc_hd__tapvpwrvgnd_1
XTAP_84 VGND VPWR sky130_fd_sc_hd__tapvpwrvgnd_1
XTAP_95 VGND VPWR sky130_fd_sc_hd__tapvpwrvgnd_1
X_338_ clknet_2_3__leaf_clk _024_ net24 VGND VGND VPWR VPWR t_save\[5\] sky130_fd_sc_hd__dfrtp_2
X_269_ t_save\[4\] _105_ VGND VGND VPWR VPWR _119_ sky130_fd_sc_hd__nand2_1
XFILLER_0_2_33 VGND VGND VPWR VPWR sky130_fd_sc_hd__fill_1
XFILLER_0_6_153 VGND VGND VPWR VPWR sky130_fd_sc_hd__decap_8
XFILLER_0_3_123 VPWR VGND VPWR VGND sky130_ef_sc_hd__decap_12
XFILLER_0_3_189 VGND VGND VPWR VPWR sky130_fd_sc_hd__fill_1
XFILLER_0_0_137 VGND VGND VPWR VPWR sky130_fd_sc_hd__decap_3
XFILLER_0_26_121 VPWR VGND VPWR VGND sky130_ef_sc_hd__decap_12
XFILLER_0_25_89 VPWR VGND VPWR VGND sky130_ef_sc_hd__decap_12
XFILLER_0_26_165 VGND VGND VPWR VPWR sky130_fd_sc_hd__decap_8
XFILLER_0_5_99 VGND VGND VPWR VPWR sky130_fd_sc_hd__decap_4
X_285_ t_crit\[5\] t_crit\[4\] VGND VGND VPWR VPWR _131_ sky130_fd_sc_hd__and2_1
X_354_ clknet_2_2__leaf_clk _001_ net26 VGND VGND VPWR VPWR dcnt\[1\] sky130_fd_sc_hd__dfrtp_1
Xinput7 stat_sel[1] VGND VGND VPWR VPWR net7 sky130_fd_sc_hd__buf_2
XTAP_63 VGND VPWR sky130_fd_sc_hd__tapvpwrvgnd_1
XTAP_74 VGND VPWR sky130_fd_sc_hd__tapvpwrvgnd_1
XTAP_85 VGND VPWR sky130_fd_sc_hd__tapvpwrvgnd_1
XTAP_96 VGND VPWR sky130_fd_sc_hd__tapvpwrvgnd_1
XFILLER_0_22_57 VGND VGND VPWR VPWR sky130_fd_sc_hd__decap_3
X_337_ clknet_2_3__leaf_clk _023_ net24 VGND VGND VPWR VPWR t_save\[4\] sky130_fd_sc_hd__dfrtp_2
X_199_ _059_ net7 VGND VGND VPWR VPWR _071_ sky130_fd_sc_hd__and2b_1
X_268_ _118_ VGND VGND VPWR VPWR _022_ sky130_fd_sc_hd__clkbuf_1
XFILLER_0_11_138 VPWR VGND VPWR VGND sky130_ef_sc_hd__decap_12
XFILLER_0_2_89 VGND VGND VPWR VPWR sky130_fd_sc_hd__fill_1
XFILLER_0_6_121 VPWR VGND VPWR VGND sky130_ef_sc_hd__decap_12
XFILLER_0_10_182 VGND VGND VPWR VPWR sky130_fd_sc_hd__decap_8
XFILLER_0_17_57 VPWR VGND VPWR VGND sky130_ef_sc_hd__decap_12
XFILLER_0_3_135 VPWR VGND VPWR VGND sky130_ef_sc_hd__decap_12
XFILLER_0_0_149 VPWR VGND VPWR VGND sky130_ef_sc_hd__decap_12
XFILLER_0_8_55 VGND VGND VPWR VPWR sky130_fd_sc_hd__decap_3
XFILLER_0_26_133 VGND VGND VPWR VPWR sky130_fd_sc_hd__decap_6
X_284_ t_crit\[0\] t_crit\[1\] t_crit\[3\] t_crit\[2\] VGND VGND VPWR VPWR _130_ sky130_fd_sc_hd__and4_1
XFILLER_0_17_166 VGND VGND VPWR VPWR sky130_fd_sc_hd__fill_2
XFILLER_0_17_111 VGND VGND VPWR VPWR sky130_fd_sc_hd__fill_1
X_353_ clknet_2_2__leaf_clk _000_ net23 VGND VGND VPWR VPWR dcnt\[0\] sky130_fd_sc_hd__dfrtp_1
XFILLER_0_11_15 VGND VGND VPWR VPWR sky130_fd_sc_hd__decap_8
XFILLER_0_23_103 VGND VGND VPWR VPWR sky130_fd_sc_hd__decap_3
XFILLER_0_14_136 VGND VGND VPWR VPWR sky130_fd_sc_hd__decap_4
XTAP_97 VGND VPWR sky130_fd_sc_hd__tapvpwrvgnd_1
XTAP_64 VGND VPWR sky130_fd_sc_hd__tapvpwrvgnd_1
XTAP_75 VGND VPWR sky130_fd_sc_hd__tapvpwrvgnd_1
XTAP_86 VGND VPWR sky130_fd_sc_hd__tapvpwrvgnd_1
XFILLER_0_20_139 VGND VGND VPWR VPWR sky130_fd_sc_hd__fill_1
XFILLER_0_9_130 VPWR VGND VPWR VGND sky130_ef_sc_hd__decap_12
X_198_ net7 net6 VGND VGND VPWR VPWR _070_ sky130_fd_sc_hd__and2b_1
X_336_ clknet_2_2__leaf_clk _022_ net23 VGND VGND VPWR VPWR t_save\[3\] sky130_fd_sc_hd__dfrtp_1
X_267_ _117_ t_save\[3\] _109_ VGND VGND VPWR VPWR _118_ sky130_fd_sc_hd__mux2_1
XFILLER_0_6_133 VGND VGND VPWR VPWR sky130_fd_sc_hd__decap_6
XFILLER_0_6_166 VGND VGND VPWR VPWR sky130_fd_sc_hd__fill_1
XFILLER_0_6_177 VPWR VGND VPWR VGND sky130_ef_sc_hd__decap_12
XFILLER_0_17_69 VGND VGND VPWR VPWR sky130_fd_sc_hd__decap_3
XFILLER_0_3_147 VPWR VGND VPWR VGND sky130_ef_sc_hd__decap_12
XFILLER_0_3_169 VPWR VGND VPWR VGND sky130_ef_sc_hd__decap_12
X_319_ clknet_2_2__leaf_clk _009_ net23 VGND VGND VPWR VPWR core.solar_available sky130_fd_sc_hd__dfrtp_2
XFILLER_0_23_90 VGND VGND VPWR VPWR sky130_fd_sc_hd__decap_3
XFILLER_0_14_15 VGND VGND VPWR VPWR sky130_fd_sc_hd__decap_8
XFILLER_0_5_57 VGND VGND VPWR VPWR sky130_fd_sc_hd__decap_8
X_283_ _044_ _082_ VGND VGND VPWR VPWR _129_ sky130_fd_sc_hd__nand2_1
X_352_ clknet_2_3__leaf_clk _037_ net24 VGND VGND VPWR VPWR prev\[2\] sky130_fd_sc_hd__dfrtp_1
XTAP_98 VGND VPWR sky130_fd_sc_hd__tapvpwrvgnd_1
XTAP_65 VGND VPWR sky130_fd_sc_hd__tapvpwrvgnd_1
XTAP_76 VGND VPWR sky130_fd_sc_hd__tapvpwrvgnd_1
XTAP_87 VGND VPWR sky130_fd_sc_hd__tapvpwrvgnd_1
XFILLER_0_11_49 VGND VGND VPWR VPWR sky130_fd_sc_hd__fill_2
XFILLER_0_9_142 VPWR VGND VPWR VGND sky130_ef_sc_hd__decap_12
XFILLER_0_22_15 VPWR VGND VPWR VGND sky130_ef_sc_hd__decap_12
X_197_ net8 _060_ _069_ VGND VGND VPWR VPWR net16 sky130_fd_sc_hd__o21a_1
XFILLER_0_13_181 VGND VGND VPWR VPWR sky130_fd_sc_hd__decap_8
X_266_ t_save\[3\] _113_ _116_ VGND VGND VPWR VPWR _117_ sky130_fd_sc_hd__o21a_1
X_335_ clknet_2_2__leaf_clk _021_ net23 VGND VGND VPWR VPWR t_save\[2\] sky130_fd_sc_hd__dfrtp_1
XFILLER_0_6_189 VGND VGND VPWR VPWR sky130_fd_sc_hd__fill_1
XFILLER_0_17_48 VGND VGND VPWR VPWR sky130_fd_sc_hd__decap_8
XFILLER_0_17_15 VGND VGND VPWR VPWR sky130_fd_sc_hd__fill_1
X_318_ clknet_2_2__leaf_clk _008_ net23 VGND VGND VPWR VPWR core.battery_level\[1\]
+ sky130_fd_sc_hd__dfrtp_4
XFILLER_0_3_159 VGND VGND VPWR VPWR sky130_fd_sc_hd__fill_2
X_249_ _038_ _103_ VGND VGND VPWR VPWR _104_ sky130_fd_sc_hd__and2_1
XFILLER_0_0_107 VGND VGND VPWR VPWR sky130_fd_sc_hd__decap_4
XFILLER_0_26_3 VPWR VGND VPWR VGND sky130_ef_sc_hd__decap_12
Xhold1 sync1\[2\] VGND VGND VPWR VPWR net29 sky130_fd_sc_hd__dlygate4sd3_1
XFILLER_0_25_15 VPWR VGND VPWR VGND sky130_ef_sc_hd__decap_12
XFILLER_0_17_113 VGND VGND VPWR VPWR sky130_fd_sc_hd__decap_8
X_351_ clknet_2_3__leaf_clk _036_ net24 VGND VGND VPWR VPWR prev\[1\] sky130_fd_sc_hd__dfrtp_1
X_282_ _128_ VGND VGND VPWR VPWR _026_ sky130_fd_sc_hd__clkbuf_1
XFILLER_0_14_127 VGND VGND VPWR VPWR sky130_fd_sc_hd__fill_2
XTAP_99 VGND VPWR sky130_fd_sc_hd__tapvpwrvgnd_1
XTAP_66 VGND VPWR sky130_fd_sc_hd__tapvpwrvgnd_1
XTAP_77 VGND VPWR sky130_fd_sc_hd__tapvpwrvgnd_1
XTAP_88 VGND VPWR sky130_fd_sc_hd__tapvpwrvgnd_1
XPHY_50 VGND VGND VPWR VPWR sky130_fd_sc_hd__decap_3
XFILLER_0_22_49 VGND VGND VPWR VPWR sky130_fd_sc_hd__decap_8
XFILLER_0_22_27 VGND VGND VPWR VPWR sky130_fd_sc_hd__fill_1
XFILLER_0_13_160 VGND VGND VPWR VPWR sky130_fd_sc_hd__decap_8
X_334_ clknet_2_2__leaf_clk _020_ net23 VGND VGND VPWR VPWR t_save\[1\] sky130_fd_sc_hd__dfrtp_2
XFILLER_0_9_154 VGND VGND VPWR VPWR sky130_fd_sc_hd__decap_4
XFILLER_0_9_176 VPWR VGND VPWR VGND sky130_ef_sc_hd__decap_12
X_265_ net3 _105_ VGND VGND VPWR VPWR _116_ sky130_fd_sc_hd__nor2_1
X_196_ t_save\[3\] _059_ _061_ t_norm\[3\] _068_ VGND VGND VPWR VPWR _069_ sky130_fd_sc_hd__a221o_1
XFILLER_0_10_141 VPWR VGND VPWR VGND sky130_ef_sc_hd__decap_12
XFILLER_0_3_105 VGND VGND VPWR VPWR sky130_fd_sc_hd__decap_6
X_179_ dcnt\[0\] dcnt\[2\] _052_ _056_ VGND VGND VPWR VPWR _057_ sky130_fd_sc_hd__and4bb_1
X_248_ t_norm\[6\] net9 _044_ _085_ t_norm\[7\] VGND VGND VPWR VPWR _103_ sky130_fd_sc_hd__a41o_1
X_317_ clknet_2_2__leaf_clk _007_ net23 VGND VGND VPWR VPWR core.battery_level\[0\]
+ sky130_fd_sc_hd__dfstp_2
XFILLER_0_3_91 VGND VGND VPWR VPWR sky130_fd_sc_hd__fill_1
Xclkbuf_2_2__f_clk clknet_0_clk VGND VGND VPWR VPWR clknet_2_2__leaf_clk sky130_fd_sc_hd__clkbuf_16
XFILLER_0_19_3 VPWR VGND VPWR VGND sky130_ef_sc_hd__decap_12
XFILLER_0_18_92 VPWR VGND VPWR VGND sky130_ef_sc_hd__decap_12
XFILLER_0_8_47 VGND VGND VPWR VPWR sky130_fd_sc_hd__decap_8
XFILLER_0_8_69 VGND VGND VPWR VPWR sky130_fd_sc_hd__fill_2
Xhold2 sync1\[1\] VGND VGND VPWR VPWR net30 sky130_fd_sc_hd__dlygate4sd3_1
XFILLER_0_0_70 VPWR VGND VPWR VGND sky130_ef_sc_hd__decap_12
XFILLER_0_25_27 VPWR VGND VPWR VGND sky130_ef_sc_hd__decap_12
XFILLER_0_8_3 VGND VGND VPWR VPWR sky130_fd_sc_hd__decap_4
XFILLER_0_5_15 VPWR VGND VPWR VGND sky130_ef_sc_hd__decap_12
X_350_ clknet_2_3__leaf_clk _035_ net24 VGND VGND VPWR VPWR prev\[0\] sky130_fd_sc_hd__dfstp_1
X_281_ _038_ _127_ VGND VGND VPWR VPWR _128_ sky130_fd_sc_hd__and2_1
XTAP_67 VGND VPWR sky130_fd_sc_hd__tapvpwrvgnd_1
XTAP_56 VGND VPWR sky130_fd_sc_hd__tapvpwrvgnd_1
XTAP_78 VGND VPWR sky130_fd_sc_hd__tapvpwrvgnd_1
XTAP_89 VGND VPWR sky130_fd_sc_hd__tapvpwrvgnd_1
XFILLER_0_20_109 VPWR VGND VPWR VGND sky130_ef_sc_hd__decap_12
XFILLER_0_9_111 VGND VGND VPWR VPWR sky130_fd_sc_hd__fill_1
XFILLER_0_9_188 VGND VGND VPWR VPWR sky130_fd_sc_hd__fill_2
XPHY_51 VGND VGND VPWR VPWR sky130_fd_sc_hd__decap_3
XPHY_40 VGND VGND VPWR VPWR sky130_fd_sc_hd__decap_3
X_195_ t_crit\[3\] _059_ net7 VGND VGND VPWR VPWR _068_ sky130_fd_sc_hd__o21a_1
XFILLER_0_2_27 VGND VGND VPWR VPWR sky130_fd_sc_hd__fill_1
X_333_ clknet_2_2__leaf_clk _019_ net23 VGND VGND VPWR VPWR t_save\[0\] sky130_fd_sc_hd__dfrtp_2
X_264_ _114_ _108_ _115_ _109_ t_save\[2\] VGND VGND VPWR VPWR _021_ sky130_fd_sc_hd__a32o_1
XFILLER_0_10_153 VGND VGND VPWR VPWR sky130_fd_sc_hd__decap_3
X_316_ _151_ VGND VGND VPWR VPWR _037_ sky130_fd_sc_hd__clkbuf_1
X_247_ _101_ _102_ VGND VGND VPWR VPWR _017_ sky130_fd_sc_hd__nor2_1
X_178_ _053_ _054_ _055_ VGND VGND VPWR VPWR _056_ sky130_fd_sc_hd__or3_1
XFILLER_0_18_71 VGND VGND VPWR VPWR sky130_fd_sc_hd__fill_1
Xhold3 sync1\[0\] VGND VGND VPWR VPWR net31 sky130_fd_sc_hd__dlygate4sd3_1
XFILLER_0_25_39 VPWR VGND VPWR VGND sky130_ef_sc_hd__decap_12
XFILLER_0_0_82 VGND VGND VPWR VPWR sky130_fd_sc_hd__fill_2
XFILLER_0_5_27 VGND VGND VPWR VPWR sky130_fd_sc_hd__decap_8
X_280_ _076_ net10 _044_ _106_ t_save\[7\] VGND VGND VPWR VPWR _127_ sky130_fd_sc_hd__a41o_1
XTAP_57 VGND VPWR sky130_fd_sc_hd__tapvpwrvgnd_1
XTAP_68 VGND VPWR sky130_fd_sc_hd__tapvpwrvgnd_1
XTAP_79 VGND VPWR sky130_fd_sc_hd__tapvpwrvgnd_1
XFILLER_0_9_167 VGND VGND VPWR VPWR sky130_fd_sc_hd__fill_1
XPHY_52 VGND VGND VPWR VPWR sky130_fd_sc_hd__decap_3
XPHY_41 VGND VGND VPWR VPWR sky130_fd_sc_hd__decap_3
XPHY_30 VGND VGND VPWR VPWR sky130_fd_sc_hd__decap_3
X_332_ clknet_2_0__leaf_clk _018_ net21 VGND VGND VPWR VPWR t_norm\[7\] sky130_fd_sc_hd__dfrtp_2
X_263_ t_save\[1\] t_save\[0\] t_save\[2\] VGND VGND VPWR VPWR _115_ sky130_fd_sc_hd__a21o_1
X_194_ core.solar_available _060_ _067_ VGND VGND VPWR VPWR net15 sky130_fd_sc_hd__o21a_1
X_315_ sync2\[2\] VGND VGND VPWR VPWR _151_ sky130_fd_sc_hd__clkbuf_1
X_246_ t_norm\[6\] _085_ _087_ _152_ VGND VGND VPWR VPWR _102_ sky130_fd_sc_hd__a31o_1
X_177_ _046_ core.battery_level\[0\] core.battery_level\[1\] _049_ VGND VGND VPWR
+ VPWR _055_ sky130_fd_sc_hd__a2bb2o_1
X_229_ t_norm\[0\] _087_ t_norm\[1\] VGND VGND VPWR VPWR _090_ sky130_fd_sc_hd__a21oi_1
XFILLER_0_18_83 VGND VGND VPWR VPWR sky130_fd_sc_hd__fill_1
Xhold4 presc\[0\] VGND VGND VPWR VPWR net32 sky130_fd_sc_hd__dlygate4sd3_1
XFILLER_0_0_50 VGND VGND VPWR VPWR sky130_fd_sc_hd__decap_6
XFILLER_0_9_81 VPWR VGND VPWR VGND sky130_ef_sc_hd__decap_12
XFILLER_0_15_84 VGND VGND VPWR VPWR sky130_fd_sc_hd__decap_4
XFILLER_0_10_9 VPWR VGND VPWR VGND sky130_ef_sc_hd__decap_12
XFILLER_0_14_119 VGND VGND VPWR VPWR sky130_fd_sc_hd__decap_8
XTAP_58 VGND VPWR sky130_fd_sc_hd__tapvpwrvgnd_1
XTAP_69 VGND VPWR sky130_fd_sc_hd__tapvpwrvgnd_1
XFILLER_0_26_83 VGND VGND VPWR VPWR sky130_fd_sc_hd__fill_1
XFILLER_0_22_141 VPWR VGND VPWR VGND sky130_ef_sc_hd__decap_12
XPHY_53 VGND VGND VPWR VPWR sky130_fd_sc_hd__decap_3
XPHY_42 VGND VGND VPWR VPWR sky130_fd_sc_hd__decap_3
XPHY_31 VGND VGND VPWR VPWR sky130_fd_sc_hd__decap_3
XFILLER_0_6_71 VGND VGND VPWR VPWR sky130_fd_sc_hd__fill_1
XFILLER_0_6_93 VGND VGND VPWR VPWR sky130_fd_sc_hd__decap_8
X_331_ clknet_2_0__leaf_clk _017_ net21 VGND VGND VPWR VPWR t_norm\[6\] sky130_fd_sc_hd__dfrtp_4
X_262_ _113_ VGND VGND VPWR VPWR _114_ sky130_fd_sc_hd__inv_2
XPHY_20 VGND VGND VPWR VPWR sky130_fd_sc_hd__decap_3
X_193_ t_save\[2\] _059_ _061_ t_norm\[2\] _066_ VGND VGND VPWR VPWR _067_ sky130_fd_sc_hd__a221o_1
XFILLER_0_2_29 VGND VGND VPWR VPWR sky130_fd_sc_hd__decap_4
XFILLER_0_10_133 VGND VGND VPWR VPWR sky130_fd_sc_hd__decap_6
XFILLER_0_12_85 VGND VGND VPWR VPWR sky130_fd_sc_hd__decap_4
X_314_ _150_ VGND VGND VPWR VPWR _036_ sky130_fd_sc_hd__clkbuf_1
X_245_ _085_ _087_ t_norm\[6\] VGND VGND VPWR VPWR _101_ sky130_fd_sc_hd__a21oi_1
X_176_ _049_ core.battery_level\[1\] core.battery_level\[0\] _046_ VGND VGND VPWR
+ VPWR _054_ sky130_fd_sc_hd__a2bb2o_1
XFILLER_0_2_141 VPWR VGND VPWR VGND sky130_ef_sc_hd__decap_12
X_159_ presc\[1\] presc\[0\] _039_ VGND VGND VPWR VPWR _040_ sky130_fd_sc_hd__o21ai_1
X_228_ _089_ VGND VGND VPWR VPWR _011_ sky130_fd_sc_hd__clkbuf_1
XFILLER_0_20_85 VPWR VGND VPWR VGND sky130_ef_sc_hd__decap_12
XFILLER_0_20_41 VPWR VGND VPWR VGND sky130_ef_sc_hd__decap_12
Xhold5 presc\[3\] VGND VGND VPWR VPWR net33 sky130_fd_sc_hd__dlygate4sd3_1
XFILLER_0_17_3 VPWR VGND VPWR VGND sky130_ef_sc_hd__decap_12
XFILLER_0_9_93 VPWR VGND VPWR VGND sky130_ef_sc_hd__decap_12
XFILLER_0_26_139 VGND VGND VPWR VPWR sky130_fd_sc_hd__fill_1
XTAP_59 VGND VPWR sky130_fd_sc_hd__tapvpwrvgnd_1
XFILLER_0_6_3 VPWR VGND VPWR VGND sky130_ef_sc_hd__decap_12
XFILLER_0_22_186 VGND VGND VPWR VPWR sky130_fd_sc_hd__decap_4
XFILLER_0_22_153 VPWR VGND VPWR VGND sky130_ef_sc_hd__decap_12
XPHY_54 VGND VGND VPWR VPWR sky130_fd_sc_hd__decap_3
XPHY_43 VGND VGND VPWR VPWR sky130_fd_sc_hd__decap_3
X_330_ clknet_2_1__leaf_clk _016_ net22 VGND VGND VPWR VPWR t_norm\[5\] sky130_fd_sc_hd__dfrtp_1
XPHY_32 VGND VGND VPWR VPWR sky130_fd_sc_hd__decap_3
X_192_ t_crit\[2\] _059_ net7 VGND VGND VPWR VPWR _066_ sky130_fd_sc_hd__o21a_1
XPHY_10 VGND VGND VPWR VPWR sky130_fd_sc_hd__decap_3
XFILLER_0_6_83 VGND VGND VPWR VPWR sky130_fd_sc_hd__fill_1
XFILLER_0_8_180 VGND VGND VPWR VPWR sky130_fd_sc_hd__decap_8
X_261_ t_save\[1\] t_save\[0\] t_save\[2\] VGND VGND VPWR VPWR _113_ sky130_fd_sc_hd__and3_1
XPHY_21 VGND VGND VPWR VPWR sky130_fd_sc_hd__decap_3
XFILLER_0_6_139 VGND VGND VPWR VPWR sky130_fd_sc_hd__fill_1
X_313_ sync2\[1\] VGND VGND VPWR VPWR _150_ sky130_fd_sc_hd__clkbuf_1
X_244_ _099_ _093_ _100_ t_norm\[5\] _039_ VGND VGND VPWR VPWR _016_ sky130_fd_sc_hd__o221a_1
X_175_ sync2\[2\] core.solar_available VGND VGND VPWR VPWR _053_ sky130_fd_sc_hd__xor2_1
XFILLER_0_2_153 VGND VGND VPWR VPWR sky130_fd_sc_hd__decap_4
XFILLER_0_3_73 VPWR VGND VPWR VGND sky130_ef_sc_hd__decap_12
X_158_ _038_ VGND VGND VPWR VPWR _039_ sky130_fd_sc_hd__clkbuf_4
X_227_ _083_ _088_ t_norm\[0\] VGND VGND VPWR VPWR _089_ sky130_fd_sc_hd__mux2_1
XFILLER_0_20_53 VPWR VGND VPWR VGND sky130_ef_sc_hd__decap_12
XFILLER_0_20_97 VPWR VGND VPWR VGND sky130_ef_sc_hd__decap_12
XFILLER_0_0_85 VPWR VGND VPWR VGND sky130_ef_sc_hd__decap_12
XFILLER_0_0_63 VGND VGND VPWR VPWR sky130_fd_sc_hd__fill_1
XFILLER_0_0_41 VGND VGND VPWR VPWR sky130_fd_sc_hd__decap_3
XFILLER_0_17_107 VGND VGND VPWR VPWR sky130_fd_sc_hd__decap_4
XFILLER_0_26_85 VPWR VGND VPWR VGND sky130_ef_sc_hd__decap_12
XFILLER_0_26_41 VPWR VGND VPWR VGND sky130_ef_sc_hd__decap_12
XPHY_55 VGND VGND VPWR VPWR sky130_fd_sc_hd__decap_3
XPHY_44 VGND VGND VPWR VPWR sky130_fd_sc_hd__decap_3
XPHY_33 VGND VGND VPWR VPWR sky130_fd_sc_hd__decap_3
XPHY_11 VGND VGND VPWR VPWR sky130_fd_sc_hd__decap_3
X_260_ _111_ _108_ _112_ _109_ t_save\[1\] VGND VGND VPWR VPWR _020_ sky130_fd_sc_hd__a32o_1
XPHY_22 VGND VGND VPWR VPWR sky130_fd_sc_hd__decap_3
X_191_ core.battery_level\[1\] _060_ _065_ VGND VGND VPWR VPWR net14 sky130_fd_sc_hd__o21a_1
XFILLER_0_12_98 VPWR VGND VPWR VGND sky130_ef_sc_hd__decap_12
X_312_ _149_ VGND VGND VPWR VPWR _035_ sky130_fd_sc_hd__clkbuf_1
X_243_ _097_ _093_ VGND VGND VPWR VPWR _100_ sky130_fd_sc_hd__nor2_1
X_174_ prev\[0\] _046_ _047_ sync2\[1\] _051_ VGND VGND VPWR VPWR _052_ sky130_fd_sc_hd__o221a_1
XFILLER_0_3_85 VGND VGND VPWR VPWR sky130_fd_sc_hd__decap_6
X_157_ net3 VGND VGND VPWR VPWR _038_ sky130_fd_sc_hd__inv_2
X_226_ net3 _087_ VGND VGND VPWR VPWR _088_ sky130_fd_sc_hd__nor2_1
XFILLER_0_24_6 VPWR VGND VPWR VGND sky130_ef_sc_hd__decap_12
XFILLER_0_20_76 VGND VGND VPWR VPWR sky130_fd_sc_hd__decap_8
XFILLER_0_20_65 VGND VGND VPWR VPWR sky130_fd_sc_hd__decap_3
XFILLER_0_0_97 VGND VGND VPWR VPWR sky130_fd_sc_hd__decap_4
X_209_ _076_ core.solar_available core.battery_level\[1\] VGND VGND VPWR VPWR _077_
+ sky130_fd_sc_hd__a21oi_1
XFILLER_0_15_54 VGND VGND VPWR VPWR sky130_fd_sc_hd__fill_2
XFILLER_0_22_3 VPWR VGND VPWR VGND sky130_ef_sc_hd__decap_12
XFILLER_0_26_97 VPWR VGND VPWR VGND sky130_ef_sc_hd__decap_12
XFILLER_0_26_53 VPWR VGND VPWR VGND sky130_ef_sc_hd__decap_12
XPHY_12 VGND VGND VPWR VPWR sky130_fd_sc_hd__decap_3
XFILLER_0_6_41 VPWR VGND VPWR VGND sky130_ef_sc_hd__decap_12
XFILLER_0_9_105 VGND VGND VPWR VPWR sky130_fd_sc_hd__decap_6
XPHY_45 VGND VGND VPWR VPWR sky130_fd_sc_hd__decap_3
XPHY_34 VGND VGND VPWR VPWR sky130_fd_sc_hd__decap_3
X_190_ t_save\[1\] _059_ _061_ t_norm\[1\] _064_ VGND VGND VPWR VPWR _065_ sky130_fd_sc_hd__a221o_1
XPHY_23 VGND VGND VPWR VPWR sky130_fd_sc_hd__decap_3
XFILLER_0_12_66 VPWR VGND VPWR VGND sky130_ef_sc_hd__decap_12
X_311_ sync2\[0\] VGND VGND VPWR VPWR _149_ sky130_fd_sc_hd__clkbuf_1
X_242_ _085_ VGND VGND VPWR VPWR _099_ sky130_fd_sc_hd__inv_2
X_173_ _048_ sync2\[0\] prev\[1\] _049_ _050_ VGND VGND VPWR VPWR _051_ sky130_fd_sc_hd__o221a_1
XFILLER_0_2_177 VPWR VGND VPWR VGND sky130_ef_sc_hd__decap_12
X_156_ _152_ net32 VGND VGND VPWR VPWR _003_ sky130_fd_sc_hd__nor2_1
X_225_ t_norm\[6\] t_norm\[7\] _085_ _086_ VGND VGND VPWR VPWR _087_ sky130_fd_sc_hd__a31oi_4
X_208_ net11 VGND VGND VPWR VPWR _076_ sky130_fd_sc_hd__inv_2
XFILLER_0_26_109 VPWR VGND VPWR VGND sky130_ef_sc_hd__decap_12
XFILLER_0_19_183 VGND VGND VPWR VPWR sky130_fd_sc_hd__fill_1
XFILLER_0_19_161 VGND VGND VPWR VPWR sky130_fd_sc_hd__fill_1
XFILLER_0_25_153 VPWR VGND VPWR VGND sky130_ef_sc_hd__decap_12
Xclkbuf_2_3__f_clk clknet_0_clk VGND VGND VPWR VPWR clknet_2_3__leaf_clk sky130_fd_sc_hd__clkbuf_16
XFILLER_0_15_88 VGND VGND VPWR VPWR sky130_fd_sc_hd__fill_1
XFILLER_0_15_77 VGND VGND VPWR VPWR sky130_fd_sc_hd__fill_1
XFILLER_0_15_3 VPWR VGND VPWR VGND sky130_ef_sc_hd__decap_12
XFILLER_0_26_65 VPWR VGND VPWR VGND sky130_ef_sc_hd__decap_12
XFILLER_0_13_189 VGND VGND VPWR VPWR sky130_fd_sc_hd__fill_1
XFILLER_0_6_53 VPWR VGND VPWR VGND sky130_ef_sc_hd__decap_12
XPHY_46 VGND VGND VPWR VPWR sky130_fd_sc_hd__decap_3
XPHY_35 VGND VGND VPWR VPWR sky130_fd_sc_hd__decap_3
XFILLER_0_4_3 VPWR VGND VPWR VGND sky130_ef_sc_hd__decap_12
XPHY_13 VGND VGND VPWR VPWR sky130_fd_sc_hd__decap_3
XPHY_24 VGND VGND VPWR VPWR sky130_fd_sc_hd__decap_3
XFILLER_0_10_104 VGND VGND VPWR VPWR sky130_fd_sc_hd__decap_4
XFILLER_0_12_89 VGND VGND VPWR VPWR sky130_fd_sc_hd__fill_1
X_310_ t_crit\[7\] _148_ _039_ VGND VGND VPWR VPWR _034_ sky130_fd_sc_hd__o21a_1
X_172_ prev\[2\] sync2\[2\] VGND VGND VPWR VPWR _050_ sky130_fd_sc_hd__xnor2_1
X_241_ _097_ _093_ _098_ t_norm\[4\] _039_ VGND VGND VPWR VPWR _015_ sky130_fd_sc_hd__o221a_1
XFILLER_0_2_189 VGND VGND VPWR VPWR sky130_fd_sc_hd__fill_1
XFILLER_0_2_134 VGND VGND VPWR VPWR sky130_fd_sc_hd__decap_6
X_155_ net3 VGND VGND VPWR VPWR _152_ sky130_fd_sc_hd__clkbuf_4
X_224_ net9 _044_ VGND VGND VPWR VPWR _086_ sky130_fd_sc_hd__nand2_1
X_207_ t_norm\[7\] _061_ _075_ VGND VGND VPWR VPWR net20 sky130_fd_sc_hd__a21o_1
XFILLER_0_25_165 VGND VGND VPWR VPWR sky130_fd_sc_hd__decap_3
XFILLER_0_26_77 VGND VGND VPWR VPWR sky130_fd_sc_hd__decap_6
XFILLER_0_13_124 VPWR VGND VPWR VGND sky130_ef_sc_hd__decap_12
XFILLER_0_13_113 VGND VGND VPWR VPWR sky130_fd_sc_hd__decap_8
XPHY_47 VGND VGND VPWR VPWR sky130_fd_sc_hd__decap_3
XPHY_36 VGND VGND VPWR VPWR sky130_fd_sc_hd__decap_3
XPHY_25 VGND VGND VPWR VPWR sky130_fd_sc_hd__decap_3
XPHY_14 VGND VGND VPWR VPWR sky130_fd_sc_hd__decap_3
XFILLER_0_6_65 VGND VGND VPWR VPWR sky130_fd_sc_hd__decap_6
X_240_ _095_ _093_ VGND VGND VPWR VPWR _098_ sky130_fd_sc_hd__nor2_1
X_171_ sync2\[1\] VGND VGND VPWR VPWR _049_ sky130_fd_sc_hd__inv_2
XFILLER_0_23_45 VGND VGND VPWR VPWR sky130_fd_sc_hd__fill_1
XFILLER_0_3_44 VPWR VGND VPWR VGND sky130_ef_sc_hd__decap_12
X_223_ t_norm\[5\] t_norm\[4\] _084_ VGND VGND VPWR VPWR _085_ sky130_fd_sc_hd__and3_2
XFILLER_0_18_67 VGND VGND VPWR VPWR sky130_fd_sc_hd__decap_4
X_154_ core.battery_level\[0\] core.battery_level\[1\] core.solar_available VGND VGND
+ VPWR VPWR core.solar_charge_enable sky130_fd_sc_hd__a21boi_1
X_206_ t_save\[7\] _070_ _071_ t_crit\[7\] VGND VGND VPWR VPWR _075_ sky130_fd_sc_hd__a22o_1
XFILLER_0_25_111 VGND VGND VPWR VPWR sky130_fd_sc_hd__fill_1
XFILLER_0_15_57 VPWR VGND VPWR VGND sky130_ef_sc_hd__decap_12
XFILLER_0_15_46 VGND VGND VPWR VPWR sky130_fd_sc_hd__decap_8
XPHY_48 VGND VGND VPWR VPWR sky130_fd_sc_hd__decap_3
XFILLER_0_20_3 VPWR VGND VPWR VGND sky130_ef_sc_hd__decap_12
XPHY_37 VGND VGND VPWR VPWR sky130_fd_sc_hd__decap_3
XFILLER_0_13_136 VPWR VGND VPWR VGND sky130_ef_sc_hd__decap_12
XPHY_26 VGND VGND VPWR VPWR sky130_fd_sc_hd__decap_3
XFILLER_0_6_77 VGND VGND VPWR VPWR sky130_fd_sc_hd__decap_6
XPHY_15 VGND VGND VPWR VPWR sky130_fd_sc_hd__decap_3
XFILLER_0_8_141 VGND VGND VPWR VPWR sky130_fd_sc_hd__decap_6
XFILLER_0_10_139 VGND VGND VPWR VPWR sky130_fd_sc_hd__fill_1
XFILLER_0_12_36 VGND VGND VPWR VPWR sky130_fd_sc_hd__decap_6
XFILLER_0_5_111 VGND VGND VPWR VPWR sky130_fd_sc_hd__fill_1
X_170_ prev\[0\] VGND VGND VPWR VPWR _048_ sky130_fd_sc_hd__inv_2
X_299_ _140_ _139_ _152_ VGND VGND VPWR VPWR _141_ sky130_fd_sc_hd__a21o_1
XFILLER_0_18_79 VGND VGND VPWR VPWR sky130_fd_sc_hd__decap_4
XFILLER_0_18_46 VGND VGND VPWR VPWR sky130_fd_sc_hd__fill_1
X_222_ t_norm\[1\] t_norm\[0\] t_norm\[3\] t_norm\[2\] VGND VGND VPWR VPWR _084_ sky130_fd_sc_hd__and4_1
X_153_ net11 net10 VGND VGND VPWR VPWR net9 sky130_fd_sc_hd__nor2_1
X_205_ t_norm\[6\] _061_ _074_ VGND VGND VPWR VPWR net19 sky130_fd_sc_hd__a21o_1
XFILLER_0_0_57 VGND VGND VPWR VPWR sky130_fd_sc_hd__decap_6
XFILLER_0_9_11 VGND VGND VPWR VPWR sky130_fd_sc_hd__decap_3
XFILLER_0_9_55 VGND VGND VPWR VPWR sky130_fd_sc_hd__fill_1
XFILLER_0_25_189 VGND VGND VPWR VPWR sky130_fd_sc_hd__fill_1
XFILLER_0_15_69 VGND VGND VPWR VPWR sky130_fd_sc_hd__decap_8
XFILLER_0_16_145 VPWR VGND VPWR VGND sky130_ef_sc_hd__decap_12
XPHY_49 VGND VGND VPWR VPWR sky130_fd_sc_hd__decap_3
XFILLER_0_21_181 VGND VGND VPWR VPWR sky130_fd_sc_hd__decap_8
XPHY_38 VGND VGND VPWR VPWR sky130_fd_sc_hd__decap_3
XPHY_27 VGND VGND VPWR VPWR sky130_fd_sc_hd__decap_3
XFILLER_0_13_148 VPWR VGND VPWR VGND sky130_ef_sc_hd__decap_12
XFILLER_0_13_104 VGND VGND VPWR VPWR sky130_fd_sc_hd__decap_8
XFILLER_0_13_3 VPWR VGND VPWR VGND sky130_ef_sc_hd__decap_12
XPHY_16 VGND VGND VPWR VPWR sky130_fd_sc_hd__decap_3
XFILLER_0_12_15 VPWR VGND VPWR VGND sky130_ef_sc_hd__decap_12
XFILLER_0_5_189 VGND VGND VPWR VPWR sky130_fd_sc_hd__fill_1
XTAP_140 VGND VPWR sky130_fd_sc_hd__tapvpwrvgnd_1
X_298_ t_crit\[4\] VGND VGND VPWR VPWR _140_ sky130_fd_sc_hd__inv_2
XFILLER_0_1_181 VGND VGND VPWR VPWR sky130_fd_sc_hd__decap_8
X_221_ _038_ net9 _044_ VGND VGND VPWR VPWR _083_ sky130_fd_sc_hd__and3_1
X_204_ t_save\[6\] _070_ _071_ t_crit\[6\] VGND VGND VPWR VPWR _074_ sky130_fd_sc_hd__a22o_1
XFILLER_0_20_15 VPWR VGND VPWR VGND sky130_ef_sc_hd__decap_12
XFILLER_0_15_15 VGND VGND VPWR VPWR sky130_fd_sc_hd__decap_3
XFILLER_0_16_157 VGND VGND VPWR VPWR sky130_fd_sc_hd__fill_1
XFILLER_0_22_116 VPWR VGND VPWR VGND sky130_ef_sc_hd__decap_12
XPHY_28 VGND VGND VPWR VPWR sky130_fd_sc_hd__decap_3
XPHY_17 VGND VGND VPWR VPWR sky130_fd_sc_hd__decap_3
XPHY_39 VGND VGND VPWR VPWR sky130_fd_sc_hd__decap_3
XFILLER_0_8_121 VPWR VGND VPWR VGND sky130_ef_sc_hd__decap_12
XFILLER_0_12_27 VGND VGND VPWR VPWR sky130_fd_sc_hd__fill_1
XFILLER_0_27_90 VPWR VGND VPWR VGND sky130_ef_sc_hd__decap_12
XTAP_141 VGND VPWR sky130_fd_sc_hd__tapvpwrvgnd_1
XTAP_130 VGND VPWR sky130_fd_sc_hd__tapvpwrvgnd_1
XFILLER_0_5_113 VPWR VGND VPWR VGND sky130_ef_sc_hd__decap_12
XFILLER_0_5_157 VGND VGND VPWR VPWR sky130_fd_sc_hd__fill_2
XFILLER_0_23_15 VPWR VGND VPWR VGND sky130_ef_sc_hd__decap_12
X_297_ t_crit\[3\] _138_ _139_ _039_ VGND VGND VPWR VPWR _030_ sky130_fd_sc_hd__o211a_1
XFILLER_0_13_81 VGND VGND VPWR VPWR sky130_fd_sc_hd__decap_3
X_220_ net8 _082_ _039_ VGND VGND VPWR VPWR _010_ sky130_fd_sc_hd__o21a_1
X_349_ clknet_2_1__leaf_clk _034_ net22 VGND VGND VPWR VPWR t_crit\[7\] sky130_fd_sc_hd__dfrtp_1
X_203_ t_norm\[5\] _061_ _073_ VGND VGND VPWR VPWR net18 sky130_fd_sc_hd__a21o_1
XFILLER_0_20_27 VGND VGND VPWR VPWR sky130_fd_sc_hd__fill_1
XFILLER_0_19_111 VGND VGND VPWR VPWR sky130_fd_sc_hd__fill_1
XFILLER_0_19_80 VGND VGND VPWR VPWR sky130_fd_sc_hd__decap_8
XFILLER_0_9_57 VPWR VGND VPWR VGND sky130_ef_sc_hd__decap_12
XFILLER_0_16_114 VGND VGND VPWR VPWR sky130_fd_sc_hd__decap_3
XFILLER_0_22_128 VPWR VGND VPWR VGND sky130_ef_sc_hd__decap_12
XFILLER_0_26_15 VPWR VGND VPWR VGND sky130_ef_sc_hd__decap_12
XPHY_29 VGND VGND VPWR VPWR sky130_fd_sc_hd__decap_3
XFILLER_0_8_133 VGND VGND VPWR VPWR sky130_fd_sc_hd__decap_6
XFILLER_0_8_188 VGND VGND VPWR VPWR sky130_fd_sc_hd__fill_2
XPHY_18 VGND VGND VPWR VPWR sky130_fd_sc_hd__decap_3
XTAP_142 VGND VPWR sky130_fd_sc_hd__tapvpwrvgnd_1
XTAP_131 VGND VPWR sky130_fd_sc_hd__tapvpwrvgnd_1
XTAP_120 VGND VPWR sky130_fd_sc_hd__tapvpwrvgnd_1
XFILLER_0_5_103 VGND VGND VPWR VPWR sky130_fd_sc_hd__fill_1
XFILLER_0_5_125 VPWR VGND VPWR VGND sky130_ef_sc_hd__decap_12
XFILLER_0_23_27 VPWR VGND VPWR VGND sky130_ef_sc_hd__decap_12
X_296_ _129_ _132_ _130_ VGND VGND VPWR VPWR _139_ sky130_fd_sc_hd__or3b_1
XFILLER_0_3_37 VGND VGND VPWR VPWR sky130_fd_sc_hd__decap_4
XFILLER_0_3_15 VGND VGND VPWR VPWR sky130_fd_sc_hd__fill_1
X_348_ clknet_2_1__leaf_clk _033_ net22 VGND VGND VPWR VPWR t_crit\[6\] sky130_fd_sc_hd__dfrtp_1
XFILLER_0_18_38 VGND VGND VPWR VPWR sky130_fd_sc_hd__decap_8
X_279_ _125_ _108_ _126_ _109_ t_save\[6\] VGND VGND VPWR VPWR _025_ sky130_fd_sc_hd__a32o_1
X_202_ t_save\[5\] _070_ _071_ t_crit\[5\] VGND VGND VPWR VPWR _073_ sky130_fd_sc_hd__a22o_1
XFILLER_0_9_69 VPWR VGND VPWR VGND sky130_ef_sc_hd__decap_12
XFILLER_0_10_83 VGND VGND VPWR VPWR sky130_fd_sc_hd__fill_1
XFILLER_0_21_82 VPWR VGND VPWR VGND sky130_ef_sc_hd__decap_12
XFILLER_0_1_81 VGND VGND VPWR VPWR sky130_fd_sc_hd__fill_2
XFILLER_0_26_27 VGND VGND VPWR VPWR sky130_fd_sc_hd__fill_1
XFILLER_0_6_15 VPWR VGND VPWR VGND sky130_ef_sc_hd__decap_12
XPHY_19 VGND VGND VPWR VPWR sky130_fd_sc_hd__decap_3
XTAP_143 VGND VPWR sky130_fd_sc_hd__tapvpwrvgnd_1
XFILLER_0_27_81 VGND VGND VPWR VPWR sky130_fd_sc_hd__decap_3
XTAP_132 VGND VPWR sky130_fd_sc_hd__tapvpwrvgnd_1
XTAP_121 VGND VPWR sky130_fd_sc_hd__tapvpwrvgnd_1
XTAP_110 VGND VPWR sky130_fd_sc_hd__tapvpwrvgnd_1
XFILLER_0_5_137 VPWR VGND VPWR VGND sky130_ef_sc_hd__decap_12
XFILLER_0_4_181 VGND VGND VPWR VPWR sky130_fd_sc_hd__decap_8
XFILLER_0_11_3 VPWR VGND VPWR VGND sky130_ef_sc_hd__decap_12
XFILLER_0_23_39 VGND VGND VPWR VPWR sky130_fd_sc_hd__decap_6
X_295_ net3 _133_ t_crit\[2\] t_crit\[1\] t_crit\[0\] VGND VGND VPWR VPWR _138_ sky130_fd_sc_hd__o2111a_1
X_347_ clknet_2_1__leaf_clk _032_ net22 VGND VGND VPWR VPWR t_crit\[5\] sky130_fd_sc_hd__dfrtp_1
X_278_ t_save\[4\] t_save\[5\] _105_ t_save\[6\] VGND VGND VPWR VPWR _126_ sky130_fd_sc_hd__a31o_1
XFILLER_0_20_29 VPWR VGND VPWR VGND sky130_ef_sc_hd__decap_12
X_201_ t_norm\[4\] _061_ _072_ VGND VGND VPWR VPWR net17 sky130_fd_sc_hd__a21o_1
XFILLER_0_4_70 VGND VGND VPWR VPWR sky130_fd_sc_hd__fill_2
XFILLER_0_4_92 VGND VGND VPWR VPWR sky130_fd_sc_hd__fill_1
XFILLER_0_10_40 VGND VGND VPWR VPWR sky130_fd_sc_hd__decap_4
XFILLER_0_19_179 VGND VGND VPWR VPWR sky130_fd_sc_hd__decap_4
XFILLER_0_19_113 VPWR VGND VPWR VGND sky130_ef_sc_hd__decap_12
XFILLER_0_21_94 VGND VGND VPWR VPWR sky130_fd_sc_hd__decap_6
XFILLER_0_15_182 VGND VGND VPWR VPWR sky130_fd_sc_hd__decap_8
XFILLER_0_16_50 VPWR VGND VPWR VGND sky130_ef_sc_hd__decap_12
XFILLER_0_6_27 VGND VGND VPWR VPWR sky130_fd_sc_hd__fill_1
XFILLER_0_8_102 VGND VGND VPWR VPWR sky130_fd_sc_hd__decap_3
XFILLER_0_8_168 VPWR VGND VPWR VGND sky130_ef_sc_hd__decap_12
XFILLER_0_12_141 VPWR VGND VPWR VGND sky130_ef_sc_hd__decap_12
XTAP_144 VGND VPWR sky130_fd_sc_hd__tapvpwrvgnd_1
XTAP_133 VGND VPWR sky130_fd_sc_hd__tapvpwrvgnd_1
XTAP_122 VGND VPWR sky130_fd_sc_hd__tapvpwrvgnd_1
XTAP_111 VGND VPWR sky130_fd_sc_hd__tapvpwrvgnd_1
XTAP_100 VGND VPWR sky130_fd_sc_hd__tapvpwrvgnd_1
XFILLER_0_5_149 VGND VGND VPWR VPWR sky130_fd_sc_hd__decap_8
.ends
